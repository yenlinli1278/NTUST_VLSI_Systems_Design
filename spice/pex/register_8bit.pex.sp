* File: register_8bit.pex.sp
* Created: Thu May 28 17:58:38 2026
* Program "Calibre xRC"
* Version "v2021.1_33.19"
*
.include "register_8bit.pex.sp.pex"
.subckt register_8bit  CLK_B CLK Q<0> Q<1> Q<2> Q<3> Q<4> Q<5> Q<6> Q<7> VSS! D<0>
+ D<1> D<2> D<3> D<4> D<5> D<6> D<7> VDD!
*
* VDD!	VDD!
* D<7>	D<7>
* D<6>	D<6>
* D<5>	D<5>
* D<4>	D<4>
* D<3>	D<3>
* D<2>	D<2>
* D<1>	D<1>
* D<0>	D<0>
* VSS!	VSS!
* Q<7>	Q<7>
* Q<6>	Q<6>
* Q<5>	Q<5>
* Q<4>	Q<4>
* Q<3>	Q<3>
* Q<2>	Q<2>
* Q<1>	Q<1>
* Q<0>	Q<0>
* CLK	CLK
* CLK_B	CLK_B
mXI7.MM1 N_D<0>_XI7.MM1_d N_CLK_B_XI7.MM1_g N_XI7.NET23_XI7.MM1_s
+ N_VSS!_XI7.MM1_b nch L=1.8e-07 W=2e-06 AD=9.6e-13 AS=5.4e-13 PD=4.96e-06
+ PS=2.54e-06 NRD=0.24 NRS=0.135
mXI7.MM8 N_XI7.NET48_XI7.MM8_d N_CLK_XI7.MM8_g N_XI7.NET23_XI7.MM8_s
+ N_VSS!_XI7.MM1_b nch L=1.8e-07 W=2e-06 AD=9.6e-13 AS=5.4e-13 PD=4.96e-06
+ PS=2.54e-06 NRD=0.24 NRS=0.135
mXI7.MM2 N_XI7.NET40_XI7.MM2_d N_XI7.NET23_XI7.MM2_g N_VSS!_XI7.MM2_s
+ N_VSS!_XI7.MM1_b nch L=1.8e-07 W=2e-06 AD=9.6e-13 AS=5.4e-13 PD=4.96e-06
+ PS=2.54e-06 NRD=0.24 NRS=0.135
mXI7.MM6 N_XI7.NET48_XI7.MM6_d N_XI7.NET40_XI7.MM6_g N_VSS!_XI7.MM6_s
+ N_VSS!_XI7.MM1_b nch L=1.8e-07 W=2e-06 AD=9.6e-13 AS=5.4e-13 PD=4.96e-06
+ PS=2.54e-06 NRD=0.24 NRS=0.135
mXI7.MM10 N_XI7.NET40_XI7.MM10_d N_CLK_XI7.MM10_g N_XI7.NET39_XI7.MM10_s
+ N_VSS!_XI7.MM1_b nch L=1.8e-07 W=2e-06 AD=9.6e-13 AS=5.4e-13 PD=4.96e-06
+ PS=2.54e-06 NRD=0.24 NRS=0.135
mXI7.MM14 N_XI7.NET24_XI7.MM14_d N_CLK_B_XI7.MM14_g N_XI7.NET39_XI7.MM14_s
+ N_VSS!_XI7.MM1_b nch L=1.8e-07 W=2e-06 AD=5.4e-13 AS=5.4e-13 PD=2.54e-06
+ PS=2.54e-06 NRD=0.135 NRS=0.135
mXI7.MM13 N_XI7.NET24_XI7.MM13_d N_Q<0>_XI7.MM13_g N_VSS!_XI7.MM13_s
+ N_VSS!_XI7.MM1_b nch L=1.8e-07 W=2e-06 AD=5.4e-13 AS=5.4e-13 PD=2.54e-06
+ PS=2.54e-06 NRD=0.135 NRS=0.135
mXI7.MM12 N_Q<0>_XI7.MM12_d N_XI7.NET39_XI7.MM12_g N_VSS!_XI7.MM12_s
+ N_VSS!_XI7.MM1_b nch L=1.8e-07 W=2e-06 AD=9.6e-13 AS=5.4e-13 PD=4.96e-06
+ PS=2.54e-06 NRD=0.24 NRS=0.135
mXI6.MM1 N_D<1>_XI6.MM1_d N_CLK_B_XI6.MM1_g N_XI6.NET23_XI6.MM1_s
+ N_VSS!_XI7.MM1_b nch L=1.8e-07 W=2e-06 AD=9.6e-13 AS=5.4e-13 PD=4.96e-06
+ PS=2.54e-06 NRD=0.24 NRS=0.135
mXI6.MM8 N_XI6.NET48_XI6.MM8_d N_CLK_XI6.MM8_g N_XI6.NET23_XI6.MM8_s
+ N_VSS!_XI7.MM1_b nch L=1.8e-07 W=2e-06 AD=9.6e-13 AS=5.4e-13 PD=4.96e-06
+ PS=2.54e-06 NRD=0.24 NRS=0.135
mXI6.MM2 N_XI6.NET40_XI6.MM2_d N_XI6.NET23_XI6.MM2_g N_VSS!_XI6.MM2_s
+ N_VSS!_XI7.MM1_b nch L=1.8e-07 W=2e-06 AD=9.6e-13 AS=5.4e-13 PD=4.96e-06
+ PS=2.54e-06 NRD=0.24 NRS=0.135
mXI6.MM6 N_XI6.NET48_XI6.MM6_d N_XI6.NET40_XI6.MM6_g N_VSS!_XI6.MM6_s
+ N_VSS!_XI7.MM1_b nch L=1.8e-07 W=2e-06 AD=9.6e-13 AS=5.4e-13 PD=4.96e-06
+ PS=2.54e-06 NRD=0.24 NRS=0.135
mXI6.MM10 N_XI6.NET40_XI6.MM10_d N_CLK_XI6.MM10_g N_XI6.NET39_XI6.MM10_s
+ N_VSS!_XI7.MM1_b nch L=1.8e-07 W=2e-06 AD=9.6e-13 AS=5.4e-13 PD=4.96e-06
+ PS=2.54e-06 NRD=0.24 NRS=0.135
mXI6.MM14 N_XI6.NET24_XI6.MM14_d N_CLK_B_XI6.MM14_g N_XI6.NET39_XI6.MM14_s
+ N_VSS!_XI7.MM1_b nch L=1.8e-07 W=2e-06 AD=5.4e-13 AS=5.4e-13 PD=2.54e-06
+ PS=2.54e-06 NRD=0.135 NRS=0.135
mXI6.MM13 N_XI6.NET24_XI6.MM13_d N_Q<1>_XI6.MM13_g N_VSS!_XI6.MM13_s
+ N_VSS!_XI7.MM1_b nch L=1.8e-07 W=2e-06 AD=5.4e-13 AS=5.4e-13 PD=2.54e-06
+ PS=2.54e-06 NRD=0.135 NRS=0.135
mXI6.MM12 N_Q<1>_XI6.MM12_d N_XI6.NET39_XI6.MM12_g N_VSS!_XI6.MM12_s
+ N_VSS!_XI7.MM1_b nch L=1.8e-07 W=2e-06 AD=9.6e-13 AS=5.4e-13 PD=4.96e-06
+ PS=2.54e-06 NRD=0.24 NRS=0.135
mXI5.MM1 N_D<2>_XI5.MM1_d N_CLK_B_XI5.MM1_g N_XI5.NET23_XI5.MM1_s
+ N_VSS!_XI7.MM1_b nch L=1.8e-07 W=2e-06 AD=9.6e-13 AS=5.4e-13 PD=4.96e-06
+ PS=2.54e-06 NRD=0.24 NRS=0.135
mXI5.MM8 N_XI5.NET48_XI5.MM8_d N_CLK_XI5.MM8_g N_XI5.NET23_XI5.MM8_s
+ N_VSS!_XI7.MM1_b nch L=1.8e-07 W=2e-06 AD=9.6e-13 AS=5.4e-13 PD=4.96e-06
+ PS=2.54e-06 NRD=0.24 NRS=0.135
mXI5.MM2 N_XI5.NET40_XI5.MM2_d N_XI5.NET23_XI5.MM2_g N_VSS!_XI5.MM2_s
+ N_VSS!_XI7.MM1_b nch L=1.8e-07 W=2e-06 AD=9.6e-13 AS=5.4e-13 PD=4.96e-06
+ PS=2.54e-06 NRD=0.24 NRS=0.135
mXI5.MM6 N_XI5.NET48_XI5.MM6_d N_XI5.NET40_XI5.MM6_g N_VSS!_XI5.MM6_s
+ N_VSS!_XI7.MM1_b nch L=1.8e-07 W=2e-06 AD=9.6e-13 AS=5.4e-13 PD=4.96e-06
+ PS=2.54e-06 NRD=0.24 NRS=0.135
mXI5.MM10 N_XI5.NET40_XI5.MM10_d N_CLK_XI5.MM10_g N_XI5.NET39_XI5.MM10_s
+ N_VSS!_XI7.MM1_b nch L=1.8e-07 W=2e-06 AD=9.6e-13 AS=5.4e-13 PD=4.96e-06
+ PS=2.54e-06 NRD=0.24 NRS=0.135
mXI5.MM14 N_XI5.NET24_XI5.MM14_d N_CLK_B_XI5.MM14_g N_XI5.NET39_XI5.MM14_s
+ N_VSS!_XI7.MM1_b nch L=1.8e-07 W=2e-06 AD=5.4e-13 AS=5.4e-13 PD=2.54e-06
+ PS=2.54e-06 NRD=0.135 NRS=0.135
mXI5.MM13 N_XI5.NET24_XI5.MM13_d N_Q<2>_XI5.MM13_g N_VSS!_XI5.MM13_s
+ N_VSS!_XI7.MM1_b nch L=1.8e-07 W=2e-06 AD=5.4e-13 AS=5.4e-13 PD=2.54e-06
+ PS=2.54e-06 NRD=0.135 NRS=0.135
mXI5.MM12 N_Q<2>_XI5.MM12_d N_XI5.NET39_XI5.MM12_g N_VSS!_XI5.MM12_s
+ N_VSS!_XI7.MM1_b nch L=1.8e-07 W=2e-06 AD=9.6e-13 AS=5.4e-13 PD=4.96e-06
+ PS=2.54e-06 NRD=0.24 NRS=0.135
mXI4.MM1 N_D<3>_XI4.MM1_d N_CLK_B_XI4.MM1_g N_XI4.NET23_XI4.MM1_s
+ N_VSS!_XI7.MM1_b nch L=1.8e-07 W=2e-06 AD=9.6e-13 AS=5.4e-13 PD=4.96e-06
+ PS=2.54e-06 NRD=0.24 NRS=0.135
mXI4.MM8 N_XI4.NET48_XI4.MM8_d N_CLK_XI4.MM8_g N_XI4.NET23_XI4.MM8_s
+ N_VSS!_XI7.MM1_b nch L=1.8e-07 W=2e-06 AD=9.6e-13 AS=5.4e-13 PD=4.96e-06
+ PS=2.54e-06 NRD=0.24 NRS=0.135
mXI4.MM2 N_XI4.NET40_XI4.MM2_d N_XI4.NET23_XI4.MM2_g N_VSS!_XI4.MM2_s
+ N_VSS!_XI7.MM1_b nch L=1.8e-07 W=2e-06 AD=9.6e-13 AS=5.4e-13 PD=4.96e-06
+ PS=2.54e-06 NRD=0.24 NRS=0.135
mXI4.MM6 N_XI4.NET48_XI4.MM6_d N_XI4.NET40_XI4.MM6_g N_VSS!_XI4.MM6_s
+ N_VSS!_XI7.MM1_b nch L=1.8e-07 W=2e-06 AD=9.6e-13 AS=5.4e-13 PD=4.96e-06
+ PS=2.54e-06 NRD=0.24 NRS=0.135
mXI4.MM10 N_XI4.NET40_XI4.MM10_d N_CLK_XI4.MM10_g N_XI4.NET39_XI4.MM10_s
+ N_VSS!_XI7.MM1_b nch L=1.8e-07 W=2e-06 AD=9.6e-13 AS=5.4e-13 PD=4.96e-06
+ PS=2.54e-06 NRD=0.24 NRS=0.135
mXI4.MM14 N_XI4.NET24_XI4.MM14_d N_CLK_B_XI4.MM14_g N_XI4.NET39_XI4.MM14_s
+ N_VSS!_XI7.MM1_b nch L=1.8e-07 W=2e-06 AD=5.4e-13 AS=5.4e-13 PD=2.54e-06
+ PS=2.54e-06 NRD=0.135 NRS=0.135
mXI4.MM13 N_XI4.NET24_XI4.MM13_d N_Q<3>_XI4.MM13_g N_VSS!_XI4.MM13_s
+ N_VSS!_XI7.MM1_b nch L=1.8e-07 W=2e-06 AD=5.4e-13 AS=5.4e-13 PD=2.54e-06
+ PS=2.54e-06 NRD=0.135 NRS=0.135
mXI4.MM12 N_Q<3>_XI4.MM12_d N_XI4.NET39_XI4.MM12_g N_VSS!_XI4.MM12_s
+ N_VSS!_XI7.MM1_b nch L=1.8e-07 W=2e-06 AD=9.6e-13 AS=5.4e-13 PD=4.96e-06
+ PS=2.54e-06 NRD=0.24 NRS=0.135
mXI3.MM1 N_D<4>_XI3.MM1_d N_CLK_B_XI3.MM1_g N_XI3.NET23_XI3.MM1_s
+ N_VSS!_XI7.MM1_b nch L=1.8e-07 W=2e-06 AD=9.6e-13 AS=5.4e-13 PD=4.96e-06
+ PS=2.54e-06 NRD=0.24 NRS=0.135
mXI3.MM8 N_XI3.NET48_XI3.MM8_d N_CLK_XI3.MM8_g N_XI3.NET23_XI3.MM8_s
+ N_VSS!_XI7.MM1_b nch L=1.8e-07 W=2e-06 AD=9.6e-13 AS=5.4e-13 PD=4.96e-06
+ PS=2.54e-06 NRD=0.24 NRS=0.135
mXI3.MM2 N_XI3.NET40_XI3.MM2_d N_XI3.NET23_XI3.MM2_g N_VSS!_XI3.MM2_s
+ N_VSS!_XI7.MM1_b nch L=1.8e-07 W=2e-06 AD=9.6e-13 AS=5.4e-13 PD=4.96e-06
+ PS=2.54e-06 NRD=0.24 NRS=0.135
mXI3.MM6 N_XI3.NET48_XI3.MM6_d N_XI3.NET40_XI3.MM6_g N_VSS!_XI3.MM6_s
+ N_VSS!_XI7.MM1_b nch L=1.8e-07 W=2e-06 AD=9.6e-13 AS=5.4e-13 PD=4.96e-06
+ PS=2.54e-06 NRD=0.24 NRS=0.135
mXI3.MM10 N_XI3.NET40_XI3.MM10_d N_CLK_XI3.MM10_g N_XI3.NET39_XI3.MM10_s
+ N_VSS!_XI7.MM1_b nch L=1.8e-07 W=2e-06 AD=9.6e-13 AS=5.4e-13 PD=4.96e-06
+ PS=2.54e-06 NRD=0.24 NRS=0.135
mXI3.MM14 N_XI3.NET24_XI3.MM14_d N_CLK_B_XI3.MM14_g N_XI3.NET39_XI3.MM14_s
+ N_VSS!_XI7.MM1_b nch L=1.8e-07 W=2e-06 AD=5.4e-13 AS=5.4e-13 PD=2.54e-06
+ PS=2.54e-06 NRD=0.135 NRS=0.135
mXI3.MM13 N_XI3.NET24_XI3.MM13_d N_Q<4>_XI3.MM13_g N_VSS!_XI3.MM13_s
+ N_VSS!_XI7.MM1_b nch L=1.8e-07 W=2e-06 AD=5.4e-13 AS=5.4e-13 PD=2.54e-06
+ PS=2.54e-06 NRD=0.135 NRS=0.135
mXI3.MM12 N_Q<4>_XI3.MM12_d N_XI3.NET39_XI3.MM12_g N_VSS!_XI3.MM12_s
+ N_VSS!_XI7.MM1_b nch L=1.8e-07 W=2e-06 AD=9.6e-13 AS=5.4e-13 PD=4.96e-06
+ PS=2.54e-06 NRD=0.24 NRS=0.135
mXI2.MM1 N_D<5>_XI2.MM1_d N_CLK_B_XI2.MM1_g N_XI2.NET23_XI2.MM1_s
+ N_VSS!_XI7.MM1_b nch L=1.8e-07 W=2e-06 AD=9.6e-13 AS=5.4e-13 PD=4.96e-06
+ PS=2.54e-06 NRD=0.24 NRS=0.135
mXI2.MM8 N_XI2.NET48_XI2.MM8_d N_CLK_XI2.MM8_g N_XI2.NET23_XI2.MM8_s
+ N_VSS!_XI7.MM1_b nch L=1.8e-07 W=2e-06 AD=9.6e-13 AS=5.4e-13 PD=4.96e-06
+ PS=2.54e-06 NRD=0.24 NRS=0.135
mXI2.MM2 N_XI2.NET40_XI2.MM2_d N_XI2.NET23_XI2.MM2_g N_VSS!_XI2.MM2_s
+ N_VSS!_XI7.MM1_b nch L=1.8e-07 W=2e-06 AD=9.6e-13 AS=5.4e-13 PD=4.96e-06
+ PS=2.54e-06 NRD=0.24 NRS=0.135
mXI2.MM6 N_XI2.NET48_XI2.MM6_d N_XI2.NET40_XI2.MM6_g N_VSS!_XI2.MM6_s
+ N_VSS!_XI7.MM1_b nch L=1.8e-07 W=2e-06 AD=9.6e-13 AS=5.4e-13 PD=4.96e-06
+ PS=2.54e-06 NRD=0.24 NRS=0.135
mXI2.MM10 N_XI2.NET40_XI2.MM10_d N_CLK_XI2.MM10_g N_XI2.NET39_XI2.MM10_s
+ N_VSS!_XI7.MM1_b nch L=1.8e-07 W=2e-06 AD=9.6e-13 AS=5.4e-13 PD=4.96e-06
+ PS=2.54e-06 NRD=0.24 NRS=0.135
mXI2.MM14 N_XI2.NET24_XI2.MM14_d N_CLK_B_XI2.MM14_g N_XI2.NET39_XI2.MM14_s
+ N_VSS!_XI7.MM1_b nch L=1.8e-07 W=2e-06 AD=5.4e-13 AS=5.4e-13 PD=2.54e-06
+ PS=2.54e-06 NRD=0.135 NRS=0.135
mXI2.MM13 N_XI2.NET24_XI2.MM13_d N_Q<5>_XI2.MM13_g N_VSS!_XI2.MM13_s
+ N_VSS!_XI7.MM1_b nch L=1.8e-07 W=2e-06 AD=5.4e-13 AS=5.4e-13 PD=2.54e-06
+ PS=2.54e-06 NRD=0.135 NRS=0.135
mXI2.MM12 N_Q<5>_XI2.MM12_d N_XI2.NET39_XI2.MM12_g N_VSS!_XI2.MM12_s
+ N_VSS!_XI7.MM1_b nch L=1.8e-07 W=2e-06 AD=9.6e-13 AS=5.4e-13 PD=4.96e-06
+ PS=2.54e-06 NRD=0.24 NRS=0.135
mXI1.MM1 N_D<6>_XI1.MM1_d N_CLK_B_XI1.MM1_g N_XI1.NET23_XI1.MM1_s
+ N_VSS!_XI7.MM1_b nch L=1.8e-07 W=2e-06 AD=9.6e-13 AS=5.4e-13 PD=4.96e-06
+ PS=2.54e-06 NRD=0.24 NRS=0.135
mXI1.MM8 N_XI1.NET48_XI1.MM8_d N_CLK_XI1.MM8_g N_XI1.NET23_XI1.MM8_s
+ N_VSS!_XI7.MM1_b nch L=1.8e-07 W=2e-06 AD=9.6e-13 AS=5.4e-13 PD=4.96e-06
+ PS=2.54e-06 NRD=0.24 NRS=0.135
mXI1.MM2 N_XI1.NET40_XI1.MM2_d N_XI1.NET23_XI1.MM2_g N_VSS!_XI1.MM2_s
+ N_VSS!_XI7.MM1_b nch L=1.8e-07 W=2e-06 AD=9.6e-13 AS=5.4e-13 PD=4.96e-06
+ PS=2.54e-06 NRD=0.24 NRS=0.135
mXI1.MM6 N_XI1.NET48_XI1.MM6_d N_XI1.NET40_XI1.MM6_g N_VSS!_XI1.MM6_s
+ N_VSS!_XI7.MM1_b nch L=1.8e-07 W=2e-06 AD=9.6e-13 AS=5.4e-13 PD=4.96e-06
+ PS=2.54e-06 NRD=0.24 NRS=0.135
mXI1.MM10 N_XI1.NET40_XI1.MM10_d N_CLK_XI1.MM10_g N_XI1.NET39_XI1.MM10_s
+ N_VSS!_XI7.MM1_b nch L=1.8e-07 W=2e-06 AD=9.6e-13 AS=5.4e-13 PD=4.96e-06
+ PS=2.54e-06 NRD=0.24 NRS=0.135
mXI1.MM14 N_XI1.NET24_XI1.MM14_d N_CLK_B_XI1.MM14_g N_XI1.NET39_XI1.MM14_s
+ N_VSS!_XI7.MM1_b nch L=1.8e-07 W=2e-06 AD=5.4e-13 AS=5.4e-13 PD=2.54e-06
+ PS=2.54e-06 NRD=0.135 NRS=0.135
mXI1.MM13 N_XI1.NET24_XI1.MM13_d N_Q<6>_XI1.MM13_g N_VSS!_XI1.MM13_s
+ N_VSS!_XI7.MM1_b nch L=1.8e-07 W=2e-06 AD=5.4e-13 AS=5.4e-13 PD=2.54e-06
+ PS=2.54e-06 NRD=0.135 NRS=0.135
mXI1.MM12 N_Q<6>_XI1.MM12_d N_XI1.NET39_XI1.MM12_g N_VSS!_XI1.MM12_s
+ N_VSS!_XI7.MM1_b nch L=1.8e-07 W=2e-06 AD=9.6e-13 AS=5.4e-13 PD=4.96e-06
+ PS=2.54e-06 NRD=0.24 NRS=0.135
mXI0.MM1 N_D<7>_XI0.MM1_d N_CLK_B_XI0.MM1_g N_XI0.NET23_XI0.MM1_s
+ N_VSS!_XI7.MM1_b nch L=1.8e-07 W=2e-06 AD=9.6e-13 AS=5.4e-13 PD=4.96e-06
+ PS=2.54e-06 NRD=0.24 NRS=0.135
mXI0.MM8 N_XI0.NET48_XI0.MM8_d N_CLK_XI0.MM8_g N_XI0.NET23_XI0.MM8_s
+ N_VSS!_XI7.MM1_b nch L=1.8e-07 W=2e-06 AD=9.6e-13 AS=5.4e-13 PD=4.96e-06
+ PS=2.54e-06 NRD=0.24 NRS=0.135
mXI0.MM2 N_XI0.NET40_XI0.MM2_d N_XI0.NET23_XI0.MM2_g N_VSS!_XI0.MM2_s
+ N_VSS!_XI7.MM1_b nch L=1.8e-07 W=2e-06 AD=9.6e-13 AS=5.4e-13 PD=4.96e-06
+ PS=2.54e-06 NRD=0.24 NRS=0.135
mXI0.MM6 N_XI0.NET48_XI0.MM6_d N_XI0.NET40_XI0.MM6_g N_VSS!_XI0.MM6_s
+ N_VSS!_XI7.MM1_b nch L=1.8e-07 W=2e-06 AD=9.6e-13 AS=5.4e-13 PD=4.96e-06
+ PS=2.54e-06 NRD=0.24 NRS=0.135
mXI0.MM10 N_XI0.NET40_XI0.MM10_d N_CLK_XI0.MM10_g N_XI0.NET39_XI0.MM10_s
+ N_VSS!_XI7.MM1_b nch L=1.8e-07 W=2e-06 AD=9.6e-13 AS=5.4e-13 PD=4.96e-06
+ PS=2.54e-06 NRD=0.24 NRS=0.135
mXI0.MM14 N_XI0.NET24_XI0.MM14_d N_CLK_B_XI0.MM14_g N_XI0.NET39_XI0.MM14_s
+ N_VSS!_XI7.MM1_b nch L=1.8e-07 W=2e-06 AD=5.4e-13 AS=5.4e-13 PD=2.54e-06
+ PS=2.54e-06 NRD=0.135 NRS=0.135
mXI0.MM13 N_XI0.NET24_XI0.MM13_d N_Q<7>_XI0.MM13_g N_VSS!_XI0.MM13_s
+ N_VSS!_XI7.MM1_b nch L=1.8e-07 W=2e-06 AD=5.4e-13 AS=5.4e-13 PD=2.54e-06
+ PS=2.54e-06 NRD=0.135 NRS=0.135
mXI0.MM12 N_Q<7>_XI0.MM12_d N_XI0.NET39_XI0.MM12_g N_VSS!_XI0.MM12_s
+ N_VSS!_XI7.MM1_b nch L=1.8e-07 W=2e-06 AD=9.6e-13 AS=5.4e-13 PD=4.96e-06
+ PS=2.54e-06 NRD=0.24 NRS=0.135
mXI7.MM0 N_D<0>_XI7.MM0_d N_CLK_XI7.MM0_g N_XI7.NET23_XI7.MM0_s N_VDD!_XI7.MM0_b
+ pch L=1.8e-07 W=4e-06 AD=1.92e-12 AS=1.08e-12 PD=8.96e-06 PS=4.54e-06 NRD=0.12
+ NRS=0.0675
mXI7.MM9 N_XI7.NET48_XI7.MM9_d N_CLK_B_XI7.MM9_g N_XI7.NET23_XI7.MM9_s
+ N_VDD!_XI7.MM0_b pch L=1.8e-07 W=4e-06 AD=1.92e-12 AS=1.08e-12 PD=8.96e-06
+ PS=4.54e-06 NRD=0.12 NRS=0.0675
mXI7.MM3 N_XI7.NET40_XI7.MM3_d N_XI7.NET23_XI7.MM3_g N_VDD!_XI7.MM3_s
+ N_VDD!_XI7.MM0_b pch L=1.8e-07 W=4e-06 AD=1.92e-12 AS=1.08e-12 PD=8.96e-06
+ PS=4.54e-06 NRD=0.12 NRS=0.0675
mXI7.MM7 N_XI7.NET48_XI7.MM7_d N_XI7.NET40_XI7.MM7_g N_VDD!_XI7.MM7_s
+ N_VDD!_XI7.MM0_b pch L=1.8e-07 W=4e-06 AD=1.92e-12 AS=1.08e-12 PD=8.96e-06
+ PS=4.54e-06 NRD=0.12 NRS=0.0675
mXI7.MM11 N_XI7.NET40_XI7.MM11_d N_CLK_B_XI7.MM11_g N_XI7.NET39_XI7.MM11_s
+ N_VDD!_XI7.MM0_b pch L=1.8e-07 W=4e-06 AD=1.92e-12 AS=1.08e-12 PD=8.96e-06
+ PS=4.54e-06 NRD=0.12 NRS=0.0675
mXI7.MM17 N_XI7.NET24_XI7.MM17_d N_CLK_XI7.MM17_g N_XI7.NET39_XI7.MM17_s
+ N_VDD!_XI7.MM0_b pch L=1.8e-07 W=4e-06 AD=1.08e-12 AS=1.08e-12 PD=4.54e-06
+ PS=4.54e-06 NRD=0.0675 NRS=0.0675
mXI7.MM16 N_XI7.NET24_XI7.MM16_d N_Q<0>_XI7.MM16_g N_VDD!_XI7.MM16_s
+ N_VDD!_XI7.MM0_b pch L=1.8e-07 W=4e-06 AD=1.08e-12 AS=1.08e-12 PD=4.54e-06
+ PS=4.54e-06 NRD=0.0675 NRS=0.0675
mXI7.MM15 N_Q<0>_XI7.MM15_d N_XI7.NET39_XI7.MM15_g N_VDD!_XI7.MM15_s
+ N_VDD!_XI7.MM0_b pch L=1.8e-07 W=4e-06 AD=1.92e-12 AS=1.08e-12 PD=8.96e-06
+ PS=4.54e-06 NRD=0.12 NRS=0.0675
mXI6.MM0 N_D<1>_XI6.MM0_d N_CLK_XI6.MM0_g N_XI6.NET23_XI6.MM0_s N_VDD!_XI7.MM0_b
+ pch L=1.8e-07 W=4e-06 AD=1.92e-12 AS=1.08e-12 PD=8.96e-06 PS=4.54e-06 NRD=0.12
+ NRS=0.0675
mXI6.MM9 N_XI6.NET48_XI6.MM9_d N_CLK_B_XI6.MM9_g N_XI6.NET23_XI6.MM9_s
+ N_VDD!_XI7.MM0_b pch L=1.8e-07 W=4e-06 AD=1.92e-12 AS=1.08e-12 PD=8.96e-06
+ PS=4.54e-06 NRD=0.12 NRS=0.0675
mXI6.MM3 N_XI6.NET40_XI6.MM3_d N_XI6.NET23_XI6.MM3_g N_VDD!_XI6.MM3_s
+ N_VDD!_XI7.MM0_b pch L=1.8e-07 W=4e-06 AD=1.92e-12 AS=1.08e-12 PD=8.96e-06
+ PS=4.54e-06 NRD=0.12 NRS=0.0675
mXI6.MM7 N_XI6.NET48_XI6.MM7_d N_XI6.NET40_XI6.MM7_g N_VDD!_XI6.MM7_s
+ N_VDD!_XI7.MM0_b pch L=1.8e-07 W=4e-06 AD=1.92e-12 AS=1.08e-12 PD=8.96e-06
+ PS=4.54e-06 NRD=0.12 NRS=0.0675
mXI6.MM11 N_XI6.NET40_XI6.MM11_d N_CLK_B_XI6.MM11_g N_XI6.NET39_XI6.MM11_s
+ N_VDD!_XI7.MM0_b pch L=1.8e-07 W=4e-06 AD=1.92e-12 AS=1.08e-12 PD=8.96e-06
+ PS=4.54e-06 NRD=0.12 NRS=0.0675
mXI6.MM17 N_XI6.NET24_XI6.MM17_d N_CLK_XI6.MM17_g N_XI6.NET39_XI6.MM17_s
+ N_VDD!_XI7.MM0_b pch L=1.8e-07 W=4e-06 AD=1.08e-12 AS=1.08e-12 PD=4.54e-06
+ PS=4.54e-06 NRD=0.0675 NRS=0.0675
mXI6.MM16 N_XI6.NET24_XI6.MM16_d N_Q<1>_XI6.MM16_g N_VDD!_XI6.MM16_s
+ N_VDD!_XI7.MM0_b pch L=1.8e-07 W=4e-06 AD=1.08e-12 AS=1.08e-12 PD=4.54e-06
+ PS=4.54e-06 NRD=0.0675 NRS=0.0675
mXI6.MM15 N_Q<1>_XI6.MM15_d N_XI6.NET39_XI6.MM15_g N_VDD!_XI6.MM15_s
+ N_VDD!_XI7.MM0_b pch L=1.8e-07 W=4e-06 AD=1.92e-12 AS=1.08e-12 PD=8.96e-06
+ PS=4.54e-06 NRD=0.12 NRS=0.0675
mXI5.MM0 N_D<2>_XI5.MM0_d N_CLK_XI5.MM0_g N_XI5.NET23_XI5.MM0_s N_VDD!_XI7.MM0_b
+ pch L=1.8e-07 W=4e-06 AD=1.92e-12 AS=1.08e-12 PD=8.96e-06 PS=4.54e-06 NRD=0.12
+ NRS=0.0675
mXI5.MM9 N_XI5.NET48_XI5.MM9_d N_CLK_B_XI5.MM9_g N_XI5.NET23_XI5.MM9_s
+ N_VDD!_XI7.MM0_b pch L=1.8e-07 W=4e-06 AD=1.92e-12 AS=1.08e-12 PD=8.96e-06
+ PS=4.54e-06 NRD=0.12 NRS=0.0675
mXI5.MM3 N_XI5.NET40_XI5.MM3_d N_XI5.NET23_XI5.MM3_g N_VDD!_XI5.MM3_s
+ N_VDD!_XI7.MM0_b pch L=1.8e-07 W=4e-06 AD=1.92e-12 AS=1.08e-12 PD=8.96e-06
+ PS=4.54e-06 NRD=0.12 NRS=0.0675
mXI5.MM7 N_XI5.NET48_XI5.MM7_d N_XI5.NET40_XI5.MM7_g N_VDD!_XI5.MM7_s
+ N_VDD!_XI7.MM0_b pch L=1.8e-07 W=4e-06 AD=1.92e-12 AS=1.08e-12 PD=8.96e-06
+ PS=4.54e-06 NRD=0.12 NRS=0.0675
mXI5.MM11 N_XI5.NET40_XI5.MM11_d N_CLK_B_XI5.MM11_g N_XI5.NET39_XI5.MM11_s
+ N_VDD!_XI7.MM0_b pch L=1.8e-07 W=4e-06 AD=1.92e-12 AS=1.08e-12 PD=8.96e-06
+ PS=4.54e-06 NRD=0.12 NRS=0.0675
mXI5.MM17 N_XI5.NET24_XI5.MM17_d N_CLK_XI5.MM17_g N_XI5.NET39_XI5.MM17_s
+ N_VDD!_XI7.MM0_b pch L=1.8e-07 W=4e-06 AD=1.08e-12 AS=1.08e-12 PD=4.54e-06
+ PS=4.54e-06 NRD=0.0675 NRS=0.0675
mXI5.MM16 N_XI5.NET24_XI5.MM16_d N_Q<2>_XI5.MM16_g N_VDD!_XI5.MM16_s
+ N_VDD!_XI7.MM0_b pch L=1.8e-07 W=4e-06 AD=1.08e-12 AS=1.08e-12 PD=4.54e-06
+ PS=4.54e-06 NRD=0.0675 NRS=0.0675
mXI5.MM15 N_Q<2>_XI5.MM15_d N_XI5.NET39_XI5.MM15_g N_VDD!_XI5.MM15_s
+ N_VDD!_XI7.MM0_b pch L=1.8e-07 W=4e-06 AD=1.92e-12 AS=1.08e-12 PD=8.96e-06
+ PS=4.54e-06 NRD=0.12 NRS=0.0675
mXI4.MM0 N_D<3>_XI4.MM0_d N_CLK_XI4.MM0_g N_XI4.NET23_XI4.MM0_s N_VDD!_XI7.MM0_b
+ pch L=1.8e-07 W=4e-06 AD=1.92e-12 AS=1.08e-12 PD=8.96e-06 PS=4.54e-06 NRD=0.12
+ NRS=0.0675
mXI4.MM9 N_XI4.NET48_XI4.MM9_d N_CLK_B_XI4.MM9_g N_XI4.NET23_XI4.MM9_s
+ N_VDD!_XI7.MM0_b pch L=1.8e-07 W=4e-06 AD=1.92e-12 AS=1.08e-12 PD=8.96e-06
+ PS=4.54e-06 NRD=0.12 NRS=0.0675
mXI4.MM3 N_XI4.NET40_XI4.MM3_d N_XI4.NET23_XI4.MM3_g N_VDD!_XI4.MM3_s
+ N_VDD!_XI7.MM0_b pch L=1.8e-07 W=4e-06 AD=1.92e-12 AS=1.08e-12 PD=8.96e-06
+ PS=4.54e-06 NRD=0.12 NRS=0.0675
mXI4.MM7 N_XI4.NET48_XI4.MM7_d N_XI4.NET40_XI4.MM7_g N_VDD!_XI4.MM7_s
+ N_VDD!_XI7.MM0_b pch L=1.8e-07 W=4e-06 AD=1.92e-12 AS=1.08e-12 PD=8.96e-06
+ PS=4.54e-06 NRD=0.12 NRS=0.0675
mXI4.MM11 N_XI4.NET40_XI4.MM11_d N_CLK_B_XI4.MM11_g N_XI4.NET39_XI4.MM11_s
+ N_VDD!_XI7.MM0_b pch L=1.8e-07 W=4e-06 AD=1.92e-12 AS=1.08e-12 PD=8.96e-06
+ PS=4.54e-06 NRD=0.12 NRS=0.0675
mXI4.MM17 N_XI4.NET24_XI4.MM17_d N_CLK_XI4.MM17_g N_XI4.NET39_XI4.MM17_s
+ N_VDD!_XI7.MM0_b pch L=1.8e-07 W=4e-06 AD=1.08e-12 AS=1.08e-12 PD=4.54e-06
+ PS=4.54e-06 NRD=0.0675 NRS=0.0675
mXI4.MM16 N_XI4.NET24_XI4.MM16_d N_Q<3>_XI4.MM16_g N_VDD!_XI4.MM16_s
+ N_VDD!_XI7.MM0_b pch L=1.8e-07 W=4e-06 AD=1.08e-12 AS=1.08e-12 PD=4.54e-06
+ PS=4.54e-06 NRD=0.0675 NRS=0.0675
mXI4.MM15 N_Q<3>_XI4.MM15_d N_XI4.NET39_XI4.MM15_g N_VDD!_XI4.MM15_s
+ N_VDD!_XI7.MM0_b pch L=1.8e-07 W=4e-06 AD=1.92e-12 AS=1.08e-12 PD=8.96e-06
+ PS=4.54e-06 NRD=0.12 NRS=0.0675
mXI3.MM0 N_D<4>_XI3.MM0_d N_CLK_XI3.MM0_g N_XI3.NET23_XI3.MM0_s N_VDD!_XI7.MM0_b
+ pch L=1.8e-07 W=4e-06 AD=1.92e-12 AS=1.08e-12 PD=8.96e-06 PS=4.54e-06 NRD=0.12
+ NRS=0.0675
mXI3.MM9 N_XI3.NET48_XI3.MM9_d N_CLK_B_XI3.MM9_g N_XI3.NET23_XI3.MM9_s
+ N_VDD!_XI7.MM0_b pch L=1.8e-07 W=4e-06 AD=1.92e-12 AS=1.08e-12 PD=8.96e-06
+ PS=4.54e-06 NRD=0.12 NRS=0.0675
mXI3.MM3 N_XI3.NET40_XI3.MM3_d N_XI3.NET23_XI3.MM3_g N_VDD!_XI3.MM3_s
+ N_VDD!_XI7.MM0_b pch L=1.8e-07 W=4e-06 AD=1.92e-12 AS=1.08e-12 PD=8.96e-06
+ PS=4.54e-06 NRD=0.12 NRS=0.0675
mXI3.MM7 N_XI3.NET48_XI3.MM7_d N_XI3.NET40_XI3.MM7_g N_VDD!_XI3.MM7_s
+ N_VDD!_XI7.MM0_b pch L=1.8e-07 W=4e-06 AD=1.92e-12 AS=1.08e-12 PD=8.96e-06
+ PS=4.54e-06 NRD=0.12 NRS=0.0675
mXI3.MM11 N_XI3.NET40_XI3.MM11_d N_CLK_B_XI3.MM11_g N_XI3.NET39_XI3.MM11_s
+ N_VDD!_XI7.MM0_b pch L=1.8e-07 W=4e-06 AD=1.92e-12 AS=1.08e-12 PD=8.96e-06
+ PS=4.54e-06 NRD=0.12 NRS=0.0675
mXI3.MM17 N_XI3.NET24_XI3.MM17_d N_CLK_XI3.MM17_g N_XI3.NET39_XI3.MM17_s
+ N_VDD!_XI7.MM0_b pch L=1.8e-07 W=4e-06 AD=1.08e-12 AS=1.08e-12 PD=4.54e-06
+ PS=4.54e-06 NRD=0.0675 NRS=0.0675
mXI3.MM16 N_XI3.NET24_XI3.MM16_d N_Q<4>_XI3.MM16_g N_VDD!_XI3.MM16_s
+ N_VDD!_XI7.MM0_b pch L=1.8e-07 W=4e-06 AD=1.08e-12 AS=1.08e-12 PD=4.54e-06
+ PS=4.54e-06 NRD=0.0675 NRS=0.0675
mXI3.MM15 N_Q<4>_XI3.MM15_d N_XI3.NET39_XI3.MM15_g N_VDD!_XI3.MM15_s
+ N_VDD!_XI7.MM0_b pch L=1.8e-07 W=4e-06 AD=1.92e-12 AS=1.08e-12 PD=8.96e-06
+ PS=4.54e-06 NRD=0.12 NRS=0.0675
mXI2.MM0 N_D<5>_XI2.MM0_d N_CLK_XI2.MM0_g N_XI2.NET23_XI2.MM0_s N_VDD!_XI7.MM0_b
+ pch L=1.8e-07 W=4e-06 AD=1.92e-12 AS=1.08e-12 PD=8.96e-06 PS=4.54e-06 NRD=0.12
+ NRS=0.0675
mXI2.MM9 N_XI2.NET48_XI2.MM9_d N_CLK_B_XI2.MM9_g N_XI2.NET23_XI2.MM9_s
+ N_VDD!_XI7.MM0_b pch L=1.8e-07 W=4e-06 AD=1.92e-12 AS=1.08e-12 PD=8.96e-06
+ PS=4.54e-06 NRD=0.12 NRS=0.0675
mXI2.MM3 N_XI2.NET40_XI2.MM3_d N_XI2.NET23_XI2.MM3_g N_VDD!_XI2.MM3_s
+ N_VDD!_XI7.MM0_b pch L=1.8e-07 W=4e-06 AD=1.92e-12 AS=1.08e-12 PD=8.96e-06
+ PS=4.54e-06 NRD=0.12 NRS=0.0675
mXI2.MM7 N_XI2.NET48_XI2.MM7_d N_XI2.NET40_XI2.MM7_g N_VDD!_XI2.MM7_s
+ N_VDD!_XI7.MM0_b pch L=1.8e-07 W=4e-06 AD=1.92e-12 AS=1.08e-12 PD=8.96e-06
+ PS=4.54e-06 NRD=0.12 NRS=0.0675
mXI2.MM11 N_XI2.NET40_XI2.MM11_d N_CLK_B_XI2.MM11_g N_XI2.NET39_XI2.MM11_s
+ N_VDD!_XI7.MM0_b pch L=1.8e-07 W=4e-06 AD=1.92e-12 AS=1.08e-12 PD=8.96e-06
+ PS=4.54e-06 NRD=0.12 NRS=0.0675
mXI2.MM17 N_XI2.NET24_XI2.MM17_d N_CLK_XI2.MM17_g N_XI2.NET39_XI2.MM17_s
+ N_VDD!_XI7.MM0_b pch L=1.8e-07 W=4e-06 AD=1.08e-12 AS=1.08e-12 PD=4.54e-06
+ PS=4.54e-06 NRD=0.0675 NRS=0.0675
mXI2.MM16 N_XI2.NET24_XI2.MM16_d N_Q<5>_XI2.MM16_g N_VDD!_XI2.MM16_s
+ N_VDD!_XI7.MM0_b pch L=1.8e-07 W=4e-06 AD=1.08e-12 AS=1.08e-12 PD=4.54e-06
+ PS=4.54e-06 NRD=0.0675 NRS=0.0675
mXI2.MM15 N_Q<5>_XI2.MM15_d N_XI2.NET39_XI2.MM15_g N_VDD!_XI2.MM15_s
+ N_VDD!_XI7.MM0_b pch L=1.8e-07 W=4e-06 AD=1.92e-12 AS=1.08e-12 PD=8.96e-06
+ PS=4.54e-06 NRD=0.12 NRS=0.0675
mXI1.MM0 N_D<6>_XI1.MM0_d N_CLK_XI1.MM0_g N_XI1.NET23_XI1.MM0_s N_VDD!_XI7.MM0_b
+ pch L=1.8e-07 W=4e-06 AD=1.92e-12 AS=1.08e-12 PD=8.96e-06 PS=4.54e-06 NRD=0.12
+ NRS=0.0675
mXI1.MM9 N_XI1.NET48_XI1.MM9_d N_CLK_B_XI1.MM9_g N_XI1.NET23_XI1.MM9_s
+ N_VDD!_XI7.MM0_b pch L=1.8e-07 W=4e-06 AD=1.92e-12 AS=1.08e-12 PD=8.96e-06
+ PS=4.54e-06 NRD=0.12 NRS=0.0675
mXI1.MM3 N_XI1.NET40_XI1.MM3_d N_XI1.NET23_XI1.MM3_g N_VDD!_XI1.MM3_s
+ N_VDD!_XI7.MM0_b pch L=1.8e-07 W=4e-06 AD=1.92e-12 AS=1.08e-12 PD=8.96e-06
+ PS=4.54e-06 NRD=0.12 NRS=0.0675
mXI1.MM7 N_XI1.NET48_XI1.MM7_d N_XI1.NET40_XI1.MM7_g N_VDD!_XI1.MM7_s
+ N_VDD!_XI7.MM0_b pch L=1.8e-07 W=4e-06 AD=1.92e-12 AS=1.08e-12 PD=8.96e-06
+ PS=4.54e-06 NRD=0.12 NRS=0.0675
mXI1.MM11 N_XI1.NET40_XI1.MM11_d N_CLK_B_XI1.MM11_g N_XI1.NET39_XI1.MM11_s
+ N_VDD!_XI7.MM0_b pch L=1.8e-07 W=4e-06 AD=1.92e-12 AS=1.08e-12 PD=8.96e-06
+ PS=4.54e-06 NRD=0.12 NRS=0.0675
mXI1.MM17 N_XI1.NET24_XI1.MM17_d N_CLK_XI1.MM17_g N_XI1.NET39_XI1.MM17_s
+ N_VDD!_XI7.MM0_b pch L=1.8e-07 W=4e-06 AD=1.08e-12 AS=1.08e-12 PD=4.54e-06
+ PS=4.54e-06 NRD=0.0675 NRS=0.0675
mXI1.MM16 N_XI1.NET24_XI1.MM16_d N_Q<6>_XI1.MM16_g N_VDD!_XI1.MM16_s
+ N_VDD!_XI7.MM0_b pch L=1.8e-07 W=4e-06 AD=1.08e-12 AS=1.08e-12 PD=4.54e-06
+ PS=4.54e-06 NRD=0.0675 NRS=0.0675
mXI1.MM15 N_Q<6>_XI1.MM15_d N_XI1.NET39_XI1.MM15_g N_VDD!_XI1.MM15_s
+ N_VDD!_XI7.MM0_b pch L=1.8e-07 W=4e-06 AD=1.92e-12 AS=1.08e-12 PD=8.96e-06
+ PS=4.54e-06 NRD=0.12 NRS=0.0675
mXI0.MM0 N_D<7>_XI0.MM0_d N_CLK_XI0.MM0_g N_XI0.NET23_XI0.MM0_s N_VDD!_XI7.MM0_b
+ pch L=1.8e-07 W=4e-06 AD=1.92e-12 AS=1.08e-12 PD=8.96e-06 PS=4.54e-06 NRD=0.12
+ NRS=0.0675
mXI0.MM9 N_XI0.NET48_XI0.MM9_d N_CLK_B_XI0.MM9_g N_XI0.NET23_XI0.MM9_s
+ N_VDD!_XI7.MM0_b pch L=1.8e-07 W=4e-06 AD=1.92e-12 AS=1.08e-12 PD=8.96e-06
+ PS=4.54e-06 NRD=0.12 NRS=0.0675
mXI0.MM3 N_XI0.NET40_XI0.MM3_d N_XI0.NET23_XI0.MM3_g N_VDD!_XI0.MM3_s
+ N_VDD!_XI7.MM0_b pch L=1.8e-07 W=4e-06 AD=1.92e-12 AS=1.08e-12 PD=8.96e-06
+ PS=4.54e-06 NRD=0.12 NRS=0.0675
mXI0.MM7 N_XI0.NET48_XI0.MM7_d N_XI0.NET40_XI0.MM7_g N_VDD!_XI0.MM7_s
+ N_VDD!_XI7.MM0_b pch L=1.8e-07 W=4e-06 AD=1.92e-12 AS=1.08e-12 PD=8.96e-06
+ PS=4.54e-06 NRD=0.12 NRS=0.0675
mXI0.MM11 N_XI0.NET40_XI0.MM11_d N_CLK_B_XI0.MM11_g N_XI0.NET39_XI0.MM11_s
+ N_VDD!_XI7.MM0_b pch L=1.8e-07 W=4e-06 AD=1.92e-12 AS=1.08e-12 PD=8.96e-06
+ PS=4.54e-06 NRD=0.12 NRS=0.0675
mXI0.MM17 N_XI0.NET24_XI0.MM17_d N_CLK_XI0.MM17_g N_XI0.NET39_XI0.MM17_s
+ N_VDD!_XI7.MM0_b pch L=1.8e-07 W=4e-06 AD=1.08e-12 AS=1.08e-12 PD=4.54e-06
+ PS=4.54e-06 NRD=0.0675 NRS=0.0675
mXI0.MM16 N_XI0.NET24_XI0.MM16_d N_Q<7>_XI0.MM16_g N_VDD!_XI0.MM16_s
+ N_VDD!_XI7.MM0_b pch L=1.8e-07 W=4e-06 AD=1.08e-12 AS=1.08e-12 PD=4.54e-06
+ PS=4.54e-06 NRD=0.0675 NRS=0.0675
mXI0.MM15 N_Q<7>_XI0.MM15_d N_XI0.NET39_XI0.MM15_g N_VDD!_XI0.MM15_s
+ N_VDD!_XI7.MM0_b pch L=1.8e-07 W=4e-06 AD=1.92e-12 AS=1.08e-12 PD=8.96e-06
+ PS=4.54e-06 NRD=0.12 NRS=0.0675
*
.include "register_8bit.pex.sp.register_8bit.pxi"
*
.ends
*
*
*********add the following lines **********
.lib "PTM180.l" cmos
.MALIAS nmos=nch
.MALIAS pmos=pch

xregister_8bit  CLK_B CLK Q<0> Q<1> Q<2> Q<3> Q<4> Q<5> Q<6> Q<7> VSS! D<0> D<1> D<2> D<3> D<4> D<5> D<6> D<7> VDD! register_8bit

vdd vdd! 0 1.8
vss vss! 0 0

VCLK  CLK   0 PULSE(0 1.8 1n 0.1n 0.1n 0.8n 2n)
VCLKB CLK_b 0 PULSE(1.8 0 1n 0.1n 0.1n 0.8n 2n)

VD0  D<0>  0  PULSE(0 1.8   2n 0.1n 0.1n   3.8n    8n)
VD1  D<1>  0  PULSE(0 1.8   4n 0.1n 0.1n   7.8n   16n)
VD2  D<2>  0  PULSE(0 1.8   8n 0.1n 0.1n  15.8n   32n)
VD3  D<3>  0  PULSE(0 1.8  16n 0.1n 0.1n  31.8n   64n)
VD4  D<4>  0  PULSE(0 1.8  32n 0.1n 0.1n  63.8n  128n)
VD5  D<5>  0  PULSE(0 1.8  64n 0.1n 0.1n 127.8n  256n)
VD6  D<6>  0  PULSE(0 1.8 128n 0.1n 0.1n 255.8n  512n)
VD7  D<7>  0  PULSE(0 1.8 256n 0.1n 0.1n 511.8n 1024n)

.trans 1ps 512ns

.option post=2
.end
