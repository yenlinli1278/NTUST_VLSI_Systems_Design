* File: incrementer_8bit.pex.sp
* Created: Fri May 29 21:37:33 2026
* Program "Calibre xRC"
* Version "v2021.1_33.19"
*
.include "incrementer_8bit.pex.sp.pex"
.subckt incrementer_8bit  Q<7> Q<6> Q<5> Q<4> Q<3> Q<2> Q<1> Q<0> VSS! D<7>
+ VDD! D<0> D<6> D<5> D<4> D<3> D<2> D<1>
*
* D<1>	D<1>
* D<2>	D<2>
* D<3>	D<3>
* D<4>	D<4>
* D<5>	D<5>
* D<6>	D<6>
* D<0>	D<0>
* VDD!	VDD!
* D<7>	D<7>
* VSS!	VSS!
* Q<0>	Q<0>
* Q<1>	Q<1>
* Q<2>	Q<2>
* Q<3>	Q<3>
* Q<4>	Q<4>
* Q<5>	Q<5>
* Q<6>	Q<6>
* Q<7>	Q<7>
mXI9.MM7 N_D<7>_XI9.MM7_d N_XI9.X_NOR_Y_XI9.MM7_g N_VSS!_XI9.MM7_s
+ N_VSS!_XI5.MM14_b nch L=1.8e-07 W=2e-06 AD=9.6e-13 AS=5.4e-13 PD=4.96e-06
+ PS=2.54e-06 NRD=0.24 NRS=0.135
mXI9.MM9 N_XI9.NET4_XI9.MM9_d N_Q<7>_XI9.MM9_g N_VSS!_XI9.MM9_s
+ N_VSS!_XI5.MM14_b nch L=1.8e-07 W=2e-06 AD=5.4e-13 AS=5.4e-13 PD=2.54e-06
+ PS=2.54e-06 NRD=0.135 NRS=0.135
mXI9.MM8 N_D<7>_XI9.MM8_d N_NET72_XI9.MM8_g N_XI9.NET4_XI9.MM8_s
+ N_VSS!_XI5.MM14_b nch L=1.8e-07 W=2e-06 AD=9.6e-13 AS=5.4e-13 PD=4.96e-06
+ PS=2.54e-06 NRD=0.24 NRS=0.135
mXI9.MM5 N_XI9.X_NOR_Y_XI9.MM5_d N_NET72_XI9.MM5_g N_VSS!_XI9.MM5_s
+ N_VSS!_XI5.MM14_b nch L=1.8e-07 W=2e-06 AD=9.6e-13 AS=5.4e-13 PD=4.96e-06
+ PS=2.54e-06 NRD=0.24 NRS=0.135
mXI9.MM6 N_XI9.X_NOR_Y_XI9.MM6_d N_Q<7>_XI9.MM6_g N_VSS!_XI9.MM6_s
+ N_VSS!_XI5.MM14_b nch L=1.8e-07 W=2e-06 AD=9.6e-13 AS=5.4e-13 PD=4.96e-06
+ PS=2.54e-06 NRD=0.24 NRS=0.135
mXI8.MM1 N_D<0>_XI8.MM1_d N_Q<0>_XI8.MM1_g N_VSS!_XI8.MM1_s N_VSS!_XI5.MM14_b
+ nch L=1.8e-07 W=2e-06 AD=9.6e-13 AS=9.6e-13 PD=4.96e-06 PS=4.96e-06 NRD=0.24
+ NRS=0.24
mXI5.MM8 N_XI5.NET7_XI5.MM8_d N_NET77_XI5.MM8_g N_VSS!_XI5.MM8_s
+ N_VSS!_XI5.MM14_b nch L=1.8e-07 W=2e-06 AD=5.4e-13 AS=5.4e-13 PD=2.54e-06
+ PS=2.54e-06 NRD=0.135 NRS=0.135
mXI5.MM7 N_XI5.NET075_XI5.MM7_d N_XI5.X_NAND_Y_XI5.MM7_g N_XI5.NET7_XI5.MM7_s
+ N_VSS!_XI5.MM14_b nch L=1.8e-07 W=2e-06 AD=9.6e-13 AS=5.4e-13 PD=4.96e-06
+ PS=2.54e-06 NRD=0.24 NRS=0.135
mXI4.MM8 N_XI4.NET7_XI4.MM8_d N_NET81_XI4.MM8_g N_VSS!_XI4.MM8_s
+ N_VSS!_XI5.MM14_b nch L=1.8e-07 W=2e-06 AD=5.4e-13 AS=5.4e-13 PD=2.54e-06
+ PS=2.54e-06 NRD=0.135 NRS=0.135
mXI4.MM7 N_XI4.NET075_XI4.MM7_d N_XI4.X_NAND_Y_XI4.MM7_g N_XI4.NET7_XI4.MM7_s
+ N_VSS!_XI5.MM14_b nch L=1.8e-07 W=2e-06 AD=9.6e-13 AS=5.4e-13 PD=4.96e-06
+ PS=2.54e-06 NRD=0.24 NRS=0.135
mXI3.MM8 N_XI3.NET7_XI3.MM8_d N_NET85_XI3.MM8_g N_VSS!_XI3.MM8_s
+ N_VSS!_XI5.MM14_b nch L=1.8e-07 W=2e-06 AD=5.4e-13 AS=5.4e-13 PD=2.54e-06
+ PS=2.54e-06 NRD=0.135 NRS=0.135
mXI3.MM7 N_XI3.NET075_XI3.MM7_d N_XI3.X_NAND_Y_XI3.MM7_g N_XI3.NET7_XI3.MM7_s
+ N_VSS!_XI5.MM14_b nch L=1.8e-07 W=2e-06 AD=9.6e-13 AS=5.4e-13 PD=4.96e-06
+ PS=2.54e-06 NRD=0.24 NRS=0.135
mXI2.MM8 N_XI2.NET7_XI2.MM8_d N_NET89_XI2.MM8_g N_VSS!_XI2.MM8_s
+ N_VSS!_XI5.MM14_b nch L=1.8e-07 W=2e-06 AD=5.4e-13 AS=5.4e-13 PD=2.54e-06
+ PS=2.54e-06 NRD=0.135 NRS=0.135
mXI2.MM7 N_XI2.NET075_XI2.MM7_d N_XI2.X_NAND_Y_XI2.MM7_g N_XI2.NET7_XI2.MM7_s
+ N_VSS!_XI5.MM14_b nch L=1.8e-07 W=2e-06 AD=9.6e-13 AS=5.4e-13 PD=4.96e-06
+ PS=2.54e-06 NRD=0.24 NRS=0.135
mXI1.MM8 N_XI1.NET7_XI1.MM8_d N_NET93_XI1.MM8_g N_VSS!_XI1.MM8_s
+ N_VSS!_XI5.MM14_b nch L=1.8e-07 W=2e-06 AD=5.4e-13 AS=5.4e-13 PD=2.54e-06
+ PS=2.54e-06 NRD=0.135 NRS=0.135
mXI1.MM7 N_XI1.NET075_XI1.MM7_d N_XI1.X_NAND_Y_XI1.MM7_g N_XI1.NET7_XI1.MM7_s
+ N_VSS!_XI5.MM14_b nch L=1.8e-07 W=2e-06 AD=9.6e-13 AS=5.4e-13 PD=4.96e-06
+ PS=2.54e-06 NRD=0.24 NRS=0.135
mXI0.MM8 N_XI0.NET7_XI0.MM8_d N_Q<0>_XI0.MM8_g N_VSS!_XI0.MM8_s
+ N_VSS!_XI5.MM14_b nch L=1.8e-07 W=2e-06 AD=5.4e-13 AS=5.4e-13 PD=2.54e-06
+ PS=2.54e-06 NRD=0.135 NRS=0.135
mXI0.MM7 N_XI0.NET075_XI0.MM7_d N_XI0.X_NAND_Y_XI0.MM7_g N_XI0.NET7_XI0.MM7_s
+ N_VSS!_XI5.MM14_b nch L=1.8e-07 W=2e-06 AD=9.6e-13 AS=5.4e-13 PD=4.96e-06
+ PS=2.54e-06 NRD=0.24 NRS=0.135
mXI5.MM9 N_XI5.NET7_XI5.MM9_d N_Q<6>_XI5.MM9_g N_VSS!_XI5.MM9_s
+ N_VSS!_XI5.MM14_b nch L=1.8e-07 W=2e-06 AD=9.6e-13 AS=5.4e-13 PD=4.96e-06
+ PS=2.54e-06 NRD=0.24 NRS=0.135
mXI4.MM9 N_XI4.NET7_XI4.MM9_d N_Q<5>_XI4.MM9_g N_VSS!_XI4.MM9_s
+ N_VSS!_XI5.MM14_b nch L=1.8e-07 W=2e-06 AD=9.6e-13 AS=5.4e-13 PD=4.96e-06
+ PS=2.54e-06 NRD=0.24 NRS=0.135
mXI3.MM9 N_XI3.NET7_XI3.MM9_d N_Q<4>_XI3.MM9_g N_VSS!_XI3.MM9_s
+ N_VSS!_XI5.MM14_b nch L=1.8e-07 W=2e-06 AD=9.6e-13 AS=5.4e-13 PD=4.96e-06
+ PS=2.54e-06 NRD=0.24 NRS=0.135
mXI2.MM9 N_XI2.NET7_XI2.MM9_d N_Q<3>_XI2.MM9_g N_VSS!_XI2.MM9_s
+ N_VSS!_XI5.MM14_b nch L=1.8e-07 W=2e-06 AD=9.6e-13 AS=5.4e-13 PD=4.96e-06
+ PS=2.54e-06 NRD=0.24 NRS=0.135
mXI1.MM9 N_XI1.NET7_XI1.MM9_d N_Q<2>_XI1.MM9_g N_VSS!_XI1.MM9_s
+ N_VSS!_XI5.MM14_b nch L=1.8e-07 W=2e-06 AD=9.6e-13 AS=5.4e-13 PD=4.96e-06
+ PS=2.54e-06 NRD=0.24 NRS=0.135
mXI0.MM9 N_XI0.NET7_XI0.MM9_d N_Q<1>_XI0.MM9_g N_VSS!_XI0.MM9_s
+ N_VSS!_XI5.MM14_b nch L=1.8e-07 W=2e-06 AD=9.6e-13 AS=5.4e-13 PD=4.96e-06
+ PS=2.54e-06 NRD=0.24 NRS=0.135
mXI9.MM4 N_D<7>_XI9.MM4_d N_XI9.X_NOR_Y_XI9.MM4_g N_XI9.NET24_XI9.MM4_s
+ N_VDD!_XI5.MM13_b pch L=1.8e-07 W=4e-06 AD=1.92e-12 AS=1.08e-12 PD=8.96e-06
+ PS=4.54e-06 NRD=0.12 NRS=0.0675
mXI9.MM3 N_XI9.NET24_XI9.MM3_d N_Q<7>_XI9.MM3_g N_VDD!_XI9.MM3_s
+ N_VDD!_XI5.MM13_b pch L=1.8e-07 W=4e-06 AD=1.08e-12 AS=1.08e-12 PD=4.54e-06
+ PS=4.54e-06 NRD=0.0675 NRS=0.0675
mXI9.MM2 N_XI9.NET24_XI9.MM2_d N_NET72_XI9.MM2_g N_VDD!_XI9.MM2_s
+ N_VDD!_XI5.MM13_b pch L=1.8e-07 W=4e-06 AD=1.92e-12 AS=1.08e-12 PD=8.96e-06
+ PS=4.54e-06 NRD=0.12 NRS=0.0675
mXI9.MM0 N_XI9.X_NOR_Y_XI9.MM0_d N_NET72_XI9.MM0_g N_XI9.NET39_XI9.MM0_s
+ N_VDD!_XI5.MM13_b pch L=1.8e-07 W=4e-06 AD=1.92e-12 AS=1.08e-12 PD=8.96e-06
+ PS=4.54e-06 NRD=0.12 NRS=0.0675
mXI9.MM1 N_XI9.NET39_XI9.MM1_d N_Q<7>_XI9.MM1_g N_VDD!_XI9.MM1_s
+ N_VDD!_XI5.MM13_b pch L=1.8e-07 W=4e-06 AD=1.08e-12 AS=1.92e-12 PD=4.54e-06
+ PS=8.96e-06 NRD=0.0675 NRS=0.12
mXI8.MM0 N_D<0>_XI8.MM0_d N_Q<0>_XI8.MM0_g N_VDD!_XI8.MM0_s N_VDD!_XI5.MM13_b
+ pch L=1.8e-07 W=4e-06 AD=1.92e-12 AS=1.92e-12 PD=8.96e-06 PS=8.96e-06 NRD=0.12
+ NRS=0.12
mXI5.MM4 N_XI5.NET30_XI5.MM4_d N_NET77_XI5.MM4_g N_VDD!_XI5.MM4_s
+ N_VDD!_XI5.MM13_b pch L=1.8e-07 W=4e-06 AD=1.08e-12 AS=1.08e-12 PD=4.54e-06
+ PS=4.54e-06 NRD=0.0675 NRS=0.0675
mXI5.MM2 N_XI5.NET075_XI5.MM2_d N_XI5.X_NAND_Y_XI5.MM2_g N_VDD!_XI5.MM2_s
+ N_VDD!_XI5.MM13_b pch L=1.8e-07 W=4e-06 AD=1.92e-12 AS=1.08e-12 PD=8.96e-06
+ PS=4.54e-06 NRD=0.12 NRS=0.0675
mXI4.MM4 N_XI4.NET30_XI4.MM4_d N_NET81_XI4.MM4_g N_VDD!_XI4.MM4_s
+ N_VDD!_XI5.MM13_b pch L=1.8e-07 W=4e-06 AD=1.08e-12 AS=1.08e-12 PD=4.54e-06
+ PS=4.54e-06 NRD=0.0675 NRS=0.0675
mXI4.MM2 N_XI4.NET075_XI4.MM2_d N_XI4.X_NAND_Y_XI4.MM2_g N_VDD!_XI4.MM2_s
+ N_VDD!_XI5.MM13_b pch L=1.8e-07 W=4e-06 AD=1.92e-12 AS=1.08e-12 PD=8.96e-06
+ PS=4.54e-06 NRD=0.12 NRS=0.0675
mXI3.MM4 N_XI3.NET30_XI3.MM4_d N_NET85_XI3.MM4_g N_VDD!_XI3.MM4_s
+ N_VDD!_XI5.MM13_b pch L=1.8e-07 W=4e-06 AD=1.08e-12 AS=1.08e-12 PD=4.54e-06
+ PS=4.54e-06 NRD=0.0675 NRS=0.0675
mXI3.MM2 N_XI3.NET075_XI3.MM2_d N_XI3.X_NAND_Y_XI3.MM2_g N_VDD!_XI3.MM2_s
+ N_VDD!_XI5.MM13_b pch L=1.8e-07 W=4e-06 AD=1.92e-12 AS=1.08e-12 PD=8.96e-06
+ PS=4.54e-06 NRD=0.12 NRS=0.0675
mXI2.MM4 N_XI2.NET30_XI2.MM4_d N_NET89_XI2.MM4_g N_VDD!_XI2.MM4_s
+ N_VDD!_XI5.MM13_b pch L=1.8e-07 W=4e-06 AD=1.08e-12 AS=1.08e-12 PD=4.54e-06
+ PS=4.54e-06 NRD=0.0675 NRS=0.0675
mXI2.MM2 N_XI2.NET075_XI2.MM2_d N_XI2.X_NAND_Y_XI2.MM2_g N_VDD!_XI2.MM2_s
+ N_VDD!_XI5.MM13_b pch L=1.8e-07 W=4e-06 AD=1.92e-12 AS=1.08e-12 PD=8.96e-06
+ PS=4.54e-06 NRD=0.12 NRS=0.0675
mXI1.MM4 N_XI1.NET30_XI1.MM4_d N_NET93_XI1.MM4_g N_VDD!_XI1.MM4_s
+ N_VDD!_XI5.MM13_b pch L=1.8e-07 W=4e-06 AD=1.08e-12 AS=1.08e-12 PD=4.54e-06
+ PS=4.54e-06 NRD=0.0675 NRS=0.0675
mXI1.MM2 N_XI1.NET075_XI1.MM2_d N_XI1.X_NAND_Y_XI1.MM2_g N_VDD!_XI1.MM2_s
+ N_VDD!_XI5.MM13_b pch L=1.8e-07 W=4e-06 AD=1.92e-12 AS=1.08e-12 PD=8.96e-06
+ PS=4.54e-06 NRD=0.12 NRS=0.0675
mXI0.MM4 N_XI0.NET30_XI0.MM4_d N_Q<0>_XI0.MM4_g N_VDD!_XI0.MM4_s
+ N_VDD!_XI5.MM13_b pch L=1.8e-07 W=4e-06 AD=1.08e-12 AS=1.08e-12 PD=4.54e-06
+ PS=4.54e-06 NRD=0.0675 NRS=0.0675
mXI0.MM2 N_XI0.NET075_XI0.MM2_d N_XI0.X_NAND_Y_XI0.MM2_g N_VDD!_XI0.MM2_s
+ N_VDD!_XI5.MM13_b pch L=1.8e-07 W=4e-06 AD=1.92e-12 AS=1.08e-12 PD=8.96e-06
+ PS=4.54e-06 NRD=0.12 NRS=0.0675
mXI5.MM3 N_XI5.NET075_XI5.MM3_d N_Q<6>_XI5.MM3_g N_XI5.NET30_XI5.MM3_s
+ N_VDD!_XI5.MM13_b pch L=1.8e-07 W=4e-06 AD=1.92e-12 AS=1.08e-12 PD=8.96e-06
+ PS=4.54e-06 NRD=0.12 NRS=0.0675
mXI4.MM3 N_XI4.NET075_XI4.MM3_d N_Q<5>_XI4.MM3_g N_XI4.NET30_XI4.MM3_s
+ N_VDD!_XI5.MM13_b pch L=1.8e-07 W=4e-06 AD=1.92e-12 AS=1.08e-12 PD=8.96e-06
+ PS=4.54e-06 NRD=0.12 NRS=0.0675
mXI3.MM3 N_XI3.NET075_XI3.MM3_d N_Q<4>_XI3.MM3_g N_XI3.NET30_XI3.MM3_s
+ N_VDD!_XI5.MM13_b pch L=1.8e-07 W=4e-06 AD=1.92e-12 AS=1.08e-12 PD=8.96e-06
+ PS=4.54e-06 NRD=0.12 NRS=0.0675
mXI2.MM3 N_XI2.NET075_XI2.MM3_d N_Q<3>_XI2.MM3_g N_XI2.NET30_XI2.MM3_s
+ N_VDD!_XI5.MM13_b pch L=1.8e-07 W=4e-06 AD=1.92e-12 AS=1.08e-12 PD=8.96e-06
+ PS=4.54e-06 NRD=0.12 NRS=0.0675
mXI1.MM3 N_XI1.NET075_XI1.MM3_d N_Q<2>_XI1.MM3_g N_XI1.NET30_XI1.MM3_s
+ N_VDD!_XI5.MM13_b pch L=1.8e-07 W=4e-06 AD=1.92e-12 AS=1.08e-12 PD=8.96e-06
+ PS=4.54e-06 NRD=0.12 NRS=0.0675
mXI0.MM3 N_XI0.NET075_XI0.MM3_d N_Q<1>_XI0.MM3_g N_XI0.NET30_XI0.MM3_s
+ N_VDD!_XI5.MM13_b pch L=1.8e-07 W=4e-06 AD=1.92e-12 AS=1.08e-12 PD=8.96e-06
+ PS=4.54e-06 NRD=0.12 NRS=0.0675
mXI5.MM14 N_D<6>_XI5.MM14_d N_XI5.NET075_XI5.MM14_g N_VSS!_XI5.MM14_s
+ N_VSS!_XI5.MM14_b nch L=1.8e-07 W=2e-06 AD=9.6e-13 AS=9.6e-13 PD=4.96e-06
+ PS=4.96e-06 NRD=0.24 NRS=0.24
mXI4.MM14 N_D<5>_XI4.MM14_d N_XI4.NET075_XI4.MM14_g N_VSS!_XI4.MM14_s
+ N_VSS!_XI5.MM14_b nch L=1.8e-07 W=2e-06 AD=9.6e-13 AS=9.6e-13 PD=4.96e-06
+ PS=4.96e-06 NRD=0.24 NRS=0.24
mXI3.MM14 N_D<4>_XI3.MM14_d N_XI3.NET075_XI3.MM14_g N_VSS!_XI3.MM14_s
+ N_VSS!_XI5.MM14_b nch L=1.8e-07 W=2e-06 AD=9.6e-13 AS=9.6e-13 PD=4.96e-06
+ PS=4.96e-06 NRD=0.24 NRS=0.24
mXI2.MM14 N_D<3>_XI2.MM14_d N_XI2.NET075_XI2.MM14_g N_VSS!_XI2.MM14_s
+ N_VSS!_XI5.MM14_b nch L=1.8e-07 W=2e-06 AD=9.6e-13 AS=9.6e-13 PD=4.96e-06
+ PS=4.96e-06 NRD=0.24 NRS=0.24
mXI1.MM14 N_D<2>_XI1.MM14_d N_XI1.NET075_XI1.MM14_g N_VSS!_XI1.MM14_s
+ N_VSS!_XI5.MM14_b nch L=1.8e-07 W=2e-06 AD=9.6e-13 AS=9.6e-13 PD=4.96e-06
+ PS=4.96e-06 NRD=0.24 NRS=0.24
mXI0.MM14 N_D<1>_XI0.MM14_d N_XI0.NET075_XI0.MM14_g N_VSS!_XI0.MM14_s
+ N_VSS!_XI5.MM14_b nch L=1.8e-07 W=2e-06 AD=9.6e-13 AS=9.6e-13 PD=4.96e-06
+ PS=4.96e-06 NRD=0.24 NRS=0.24
mXI5.MM13 N_D<6>_XI5.MM13_d N_XI5.NET075_XI5.MM13_g N_VDD!_XI5.MM13_s
+ N_VDD!_XI5.MM13_b pch L=1.8e-07 W=4e-06 AD=1.92e-12 AS=1.92e-12 PD=8.96e-06
+ PS=8.96e-06 NRD=0.12 NRS=0.12
mXI4.MM13 N_D<5>_XI4.MM13_d N_XI4.NET075_XI4.MM13_g N_VDD!_XI4.MM13_s
+ N_VDD!_XI5.MM13_b pch L=1.8e-07 W=4e-06 AD=1.92e-12 AS=1.92e-12 PD=8.96e-06
+ PS=8.96e-06 NRD=0.12 NRS=0.12
mXI3.MM13 N_D<4>_XI3.MM13_d N_XI3.NET075_XI3.MM13_g N_VDD!_XI3.MM13_s
+ N_VDD!_XI5.MM13_b pch L=1.8e-07 W=4e-06 AD=1.92e-12 AS=1.92e-12 PD=8.96e-06
+ PS=8.96e-06 NRD=0.12 NRS=0.12
mXI2.MM13 N_D<3>_XI2.MM13_d N_XI2.NET075_XI2.MM13_g N_VDD!_XI2.MM13_s
+ N_VDD!_XI5.MM13_b pch L=1.8e-07 W=4e-06 AD=1.92e-12 AS=1.92e-12 PD=8.96e-06
+ PS=8.96e-06 NRD=0.12 NRS=0.12
mXI1.MM13 N_D<2>_XI1.MM13_d N_XI1.NET075_XI1.MM13_g N_VDD!_XI1.MM13_s
+ N_VDD!_XI5.MM13_b pch L=1.8e-07 W=4e-06 AD=1.92e-12 AS=1.92e-12 PD=8.96e-06
+ PS=8.96e-06 NRD=0.12 NRS=0.12
mXI0.MM13 N_D<1>_XI0.MM13_d N_XI0.NET075_XI0.MM13_g N_VDD!_XI0.MM13_s
+ N_VDD!_XI5.MM13_b pch L=1.8e-07 W=4e-06 AD=1.92e-12 AS=1.92e-12 PD=8.96e-06
+ PS=8.96e-06 NRD=0.12 NRS=0.12
mXI5.MM11 N_NET72_XI5.MM11_d N_XI5.X_NAND_Y_XI5.MM11_g N_VSS!_XI5.MM11_s
+ N_VSS!_XI5.MM14_b nch L=1.8e-07 W=2e-06 AD=9.6e-13 AS=9.6e-13 PD=4.96e-06
+ PS=4.96e-06 NRD=0.24 NRS=0.24
mXI5.MM6 N_XI5.NET15_XI5.MM6_d N_Q<6>_XI5.MM6_g N_VSS!_XI5.MM6_s
+ N_VSS!_XI5.MM14_b nch L=1.8e-07 W=2e-06 AD=5.4e-13 AS=9.6e-13 PD=2.54e-06
+ PS=4.96e-06 NRD=0.135 NRS=0.24
mXI5.MM5 N_XI5.X_NAND_Y_XI5.MM5_d N_NET77_XI5.MM5_g N_XI5.NET15_XI5.MM5_s
+ N_VSS!_XI5.MM14_b nch L=1.8e-07 W=2e-06 AD=9.6e-13 AS=5.4e-13 PD=4.96e-06
+ PS=2.54e-06 NRD=0.24 NRS=0.135
mXI5.MM12 N_NET72_XI5.MM12_d N_XI5.X_NAND_Y_XI5.MM12_g N_VDD!_XI5.MM12_s
+ N_VDD!_XI5.MM13_b pch L=1.8e-07 W=4e-06 AD=1.92e-12 AS=1.92e-12 PD=8.96e-06
+ PS=8.96e-06 NRD=0.12 NRS=0.12
mXI5.MM1 N_XI5.X_NAND_Y_XI5.MM1_d N_Q<6>_XI5.MM1_g N_VDD!_XI5.MM1_s
+ N_VDD!_XI5.MM13_b pch L=1.8e-07 W=4e-06 AD=1.92e-12 AS=1.08e-12 PD=8.96e-06
+ PS=4.54e-06 NRD=0.12 NRS=0.0675
mXI5.MM0 N_XI5.X_NAND_Y_XI5.MM0_d N_NET77_XI5.MM0_g N_VDD!_XI5.MM0_s
+ N_VDD!_XI5.MM13_b pch L=1.8e-07 W=4e-06 AD=1.92e-12 AS=1.08e-12 PD=8.96e-06
+ PS=4.54e-06 NRD=0.12 NRS=0.0675
mXI4.MM11 N_NET77_XI4.MM11_d N_XI4.X_NAND_Y_XI4.MM11_g N_VSS!_XI4.MM11_s
+ N_VSS!_XI5.MM14_b nch L=1.8e-07 W=2e-06 AD=9.6e-13 AS=9.6e-13 PD=4.96e-06
+ PS=4.96e-06 NRD=0.24 NRS=0.24
mXI4.MM6 N_XI4.NET15_XI4.MM6_d N_Q<5>_XI4.MM6_g N_VSS!_XI4.MM6_s
+ N_VSS!_XI5.MM14_b nch L=1.8e-07 W=2e-06 AD=5.4e-13 AS=9.6e-13 PD=2.54e-06
+ PS=4.96e-06 NRD=0.135 NRS=0.24
mXI4.MM5 N_XI4.X_NAND_Y_XI4.MM5_d N_NET81_XI4.MM5_g N_XI4.NET15_XI4.MM5_s
+ N_VSS!_XI5.MM14_b nch L=1.8e-07 W=2e-06 AD=9.6e-13 AS=5.4e-13 PD=4.96e-06
+ PS=2.54e-06 NRD=0.24 NRS=0.135
mXI4.MM12 N_NET77_XI4.MM12_d N_XI4.X_NAND_Y_XI4.MM12_g N_VDD!_XI4.MM12_s
+ N_VDD!_XI5.MM13_b pch L=1.8e-07 W=4e-06 AD=1.92e-12 AS=1.92e-12 PD=8.96e-06
+ PS=8.96e-06 NRD=0.12 NRS=0.12
mXI4.MM1 N_XI4.X_NAND_Y_XI4.MM1_d N_Q<5>_XI4.MM1_g N_VDD!_XI4.MM1_s
+ N_VDD!_XI5.MM13_b pch L=1.8e-07 W=4e-06 AD=1.92e-12 AS=1.08e-12 PD=8.96e-06
+ PS=4.54e-06 NRD=0.12 NRS=0.0675
mXI4.MM0 N_XI4.X_NAND_Y_XI4.MM0_d N_NET81_XI4.MM0_g N_VDD!_XI4.MM0_s
+ N_VDD!_XI5.MM13_b pch L=1.8e-07 W=4e-06 AD=1.92e-12 AS=1.08e-12 PD=8.96e-06
+ PS=4.54e-06 NRD=0.12 NRS=0.0675
mXI3.MM11 N_NET81_XI3.MM11_d N_XI3.X_NAND_Y_XI3.MM11_g N_VSS!_XI3.MM11_s
+ N_VSS!_XI5.MM14_b nch L=1.8e-07 W=2e-06 AD=9.6e-13 AS=9.6e-13 PD=4.96e-06
+ PS=4.96e-06 NRD=0.24 NRS=0.24
mXI3.MM6 N_XI3.NET15_XI3.MM6_d N_Q<4>_XI3.MM6_g N_VSS!_XI3.MM6_s
+ N_VSS!_XI5.MM14_b nch L=1.8e-07 W=2e-06 AD=5.4e-13 AS=9.6e-13 PD=2.54e-06
+ PS=4.96e-06 NRD=0.135 NRS=0.24
mXI3.MM5 N_XI3.X_NAND_Y_XI3.MM5_d N_NET85_XI3.MM5_g N_XI3.NET15_XI3.MM5_s
+ N_VSS!_XI5.MM14_b nch L=1.8e-07 W=2e-06 AD=9.6e-13 AS=5.4e-13 PD=4.96e-06
+ PS=2.54e-06 NRD=0.24 NRS=0.135
mXI3.MM12 N_NET81_XI3.MM12_d N_XI3.X_NAND_Y_XI3.MM12_g N_VDD!_XI3.MM12_s
+ N_VDD!_XI5.MM13_b pch L=1.8e-07 W=4e-06 AD=1.92e-12 AS=1.92e-12 PD=8.96e-06
+ PS=8.96e-06 NRD=0.12 NRS=0.12
mXI3.MM1 N_XI3.X_NAND_Y_XI3.MM1_d N_Q<4>_XI3.MM1_g N_VDD!_XI3.MM1_s
+ N_VDD!_XI5.MM13_b pch L=1.8e-07 W=4e-06 AD=1.92e-12 AS=1.08e-12 PD=8.96e-06
+ PS=4.54e-06 NRD=0.12 NRS=0.0675
mXI3.MM0 N_XI3.X_NAND_Y_XI3.MM0_d N_NET85_XI3.MM0_g N_VDD!_XI3.MM0_s
+ N_VDD!_XI5.MM13_b pch L=1.8e-07 W=4e-06 AD=1.92e-12 AS=1.08e-12 PD=8.96e-06
+ PS=4.54e-06 NRD=0.12 NRS=0.0675
mXI2.MM11 N_NET85_XI2.MM11_d N_XI2.X_NAND_Y_XI2.MM11_g N_VSS!_XI2.MM11_s
+ N_VSS!_XI5.MM14_b nch L=1.8e-07 W=2e-06 AD=9.6e-13 AS=9.6e-13 PD=4.96e-06
+ PS=4.96e-06 NRD=0.24 NRS=0.24
mXI2.MM6 N_XI2.NET15_XI2.MM6_d N_Q<3>_XI2.MM6_g N_VSS!_XI2.MM6_s
+ N_VSS!_XI5.MM14_b nch L=1.8e-07 W=2e-06 AD=5.4e-13 AS=9.6e-13 PD=2.54e-06
+ PS=4.96e-06 NRD=0.135 NRS=0.24
mXI2.MM5 N_XI2.X_NAND_Y_XI2.MM5_d N_NET89_XI2.MM5_g N_XI2.NET15_XI2.MM5_s
+ N_VSS!_XI5.MM14_b nch L=1.8e-07 W=2e-06 AD=9.6e-13 AS=5.4e-13 PD=4.96e-06
+ PS=2.54e-06 NRD=0.24 NRS=0.135
mXI2.MM12 N_NET85_XI2.MM12_d N_XI2.X_NAND_Y_XI2.MM12_g N_VDD!_XI2.MM12_s
+ N_VDD!_XI5.MM13_b pch L=1.8e-07 W=4e-06 AD=1.92e-12 AS=1.92e-12 PD=8.96e-06
+ PS=8.96e-06 NRD=0.12 NRS=0.12
mXI2.MM1 N_XI2.X_NAND_Y_XI2.MM1_d N_Q<3>_XI2.MM1_g N_VDD!_XI2.MM1_s
+ N_VDD!_XI5.MM13_b pch L=1.8e-07 W=4e-06 AD=1.92e-12 AS=1.08e-12 PD=8.96e-06
+ PS=4.54e-06 NRD=0.12 NRS=0.0675
mXI2.MM0 N_XI2.X_NAND_Y_XI2.MM0_d N_NET89_XI2.MM0_g N_VDD!_XI2.MM0_s
+ N_VDD!_XI5.MM13_b pch L=1.8e-07 W=4e-06 AD=1.92e-12 AS=1.08e-12 PD=8.96e-06
+ PS=4.54e-06 NRD=0.12 NRS=0.0675
mXI1.MM11 N_NET89_XI1.MM11_d N_XI1.X_NAND_Y_XI1.MM11_g N_VSS!_XI1.MM11_s
+ N_VSS!_XI5.MM14_b nch L=1.8e-07 W=2e-06 AD=9.6e-13 AS=9.6e-13 PD=4.96e-06
+ PS=4.96e-06 NRD=0.24 NRS=0.24
mXI1.MM6 N_XI1.NET15_XI1.MM6_d N_Q<2>_XI1.MM6_g N_VSS!_XI1.MM6_s
+ N_VSS!_XI5.MM14_b nch L=1.8e-07 W=2e-06 AD=5.4e-13 AS=9.6e-13 PD=2.54e-06
+ PS=4.96e-06 NRD=0.135 NRS=0.24
mXI1.MM5 N_XI1.X_NAND_Y_XI1.MM5_d N_NET93_XI1.MM5_g N_XI1.NET15_XI1.MM5_s
+ N_VSS!_XI5.MM14_b nch L=1.8e-07 W=2e-06 AD=9.6e-13 AS=5.4e-13 PD=4.96e-06
+ PS=2.54e-06 NRD=0.24 NRS=0.135
mXI1.MM12 N_NET89_XI1.MM12_d N_XI1.X_NAND_Y_XI1.MM12_g N_VDD!_XI1.MM12_s
+ N_VDD!_XI5.MM13_b pch L=1.8e-07 W=4e-06 AD=1.92e-12 AS=1.92e-12 PD=8.96e-06
+ PS=8.96e-06 NRD=0.12 NRS=0.12
mXI1.MM1 N_XI1.X_NAND_Y_XI1.MM1_d N_Q<2>_XI1.MM1_g N_VDD!_XI1.MM1_s
+ N_VDD!_XI5.MM13_b pch L=1.8e-07 W=4e-06 AD=1.92e-12 AS=1.08e-12 PD=8.96e-06
+ PS=4.54e-06 NRD=0.12 NRS=0.0675
mXI1.MM0 N_XI1.X_NAND_Y_XI1.MM0_d N_NET93_XI1.MM0_g N_VDD!_XI1.MM0_s
+ N_VDD!_XI5.MM13_b pch L=1.8e-07 W=4e-06 AD=1.92e-12 AS=1.08e-12 PD=8.96e-06
+ PS=4.54e-06 NRD=0.12 NRS=0.0675
mXI0.MM11 N_NET93_XI0.MM11_d N_XI0.X_NAND_Y_XI0.MM11_g N_VSS!_XI0.MM11_s
+ N_VSS!_XI5.MM14_b nch L=1.8e-07 W=2e-06 AD=9.6e-13 AS=9.6e-13 PD=4.96e-06
+ PS=4.96e-06 NRD=0.24 NRS=0.24
mXI0.MM6 N_XI0.NET15_XI0.MM6_d N_Q<1>_XI0.MM6_g N_VSS!_XI0.MM6_s
+ N_VSS!_XI5.MM14_b nch L=1.8e-07 W=2e-06 AD=5.4e-13 AS=9.6e-13 PD=2.54e-06
+ PS=4.96e-06 NRD=0.135 NRS=0.24
mXI0.MM5 N_XI0.X_NAND_Y_XI0.MM5_d N_Q<0>_XI0.MM5_g N_XI0.NET15_XI0.MM5_s
+ N_VSS!_XI5.MM14_b nch L=1.8e-07 W=2e-06 AD=9.6e-13 AS=5.4e-13 PD=4.96e-06
+ PS=2.54e-06 NRD=0.24 NRS=0.135
mXI0.MM12 N_NET93_XI0.MM12_d N_XI0.X_NAND_Y_XI0.MM12_g N_VDD!_XI0.MM12_s
+ N_VDD!_XI5.MM13_b pch L=1.8e-07 W=4e-06 AD=1.92e-12 AS=1.92e-12 PD=8.96e-06
+ PS=8.96e-06 NRD=0.12 NRS=0.12
mXI0.MM1 N_XI0.X_NAND_Y_XI0.MM1_d N_Q<1>_XI0.MM1_g N_VDD!_XI0.MM1_s
+ N_VDD!_XI5.MM13_b pch L=1.8e-07 W=4e-06 AD=1.92e-12 AS=1.08e-12 PD=8.96e-06
+ PS=4.54e-06 NRD=0.12 NRS=0.0675
mXI0.MM0 N_XI0.X_NAND_Y_XI0.MM0_d N_Q<0>_XI0.MM0_g N_VDD!_XI0.MM0_s
+ N_VDD!_XI5.MM13_b pch L=1.8e-07 W=4e-06 AD=1.92e-12 AS=1.08e-12 PD=8.96e-06
+ PS=4.54e-06 NRD=0.12 NRS=0.0675
*
.include "incrementer_8bit.pex.sp.incrementer_8bit.pxi"
*
.ends
*
*
*********add the following lines **********
.lib "PTM180.l" cmos
.MALIAS nmos=nch
.MALIAS pmos=pch

xincrementer_8bit Q<7> Q<6> Q<5> Q<4> Q<3> Q<2> Q<1> Q<0> VSS! D<7> VDD! D<0> D<6> D<5> D<4> D<3> D<2> D<1> incrementer_8bit

vdd vdd! 0 1.8
vss vss! 0 0

VQ0  Q<0>  0  PULSE(0 1.8 1n   0.1n 0.1n 0.8n     2n)
VQ1  Q<1>  0  PULSE(0 1.8 2n   0.1n 0.1n 1.8n     4n)
VQ2  Q<2>  0  PULSE(0 1.8 4n   0.1n 0.1n 3.8n     8n)
VQ3  Q<3>  0  PULSE(0 1.8 8n   0.1n 0.1n 7.8n    16n)
VQ4  Q<4>  0  PULSE(0 1.8 16n  0.1n 0.1n 15.8n   32n)
VQ5  Q<5>  0  PULSE(0 1.8 32n  0.1n 0.1n 31.8n   64n)
VQ6  Q<6>  0  PULSE(0 1.8 64n  0.1n 0.1n 63.8n  128n)
VQ7  Q<7>  0  PULSE(0 1.8 128n 0.1n 0.1n 127.8n 256n)

.tran 1ps 256ns

.option post=2
.end
