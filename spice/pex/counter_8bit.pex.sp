* File: counter_8bit.pex.sp
* Created: Sat May 30 02:57:44 2026
* Program "Calibre xRC"
* Version "v2021.1_33.19"
*
.include "counter_8bit.pex.sp.pex"
.subckt counter_8bit  CLK CNT<7> CNT<6> CNT<5> CNT<4> CNT<3> CNT<2> CNT<1> CNT<0>
+ VDD! VSS!
*
* VSS!	VSS!
* VDD!	VDD!
* CNT<0>	CNT<0>
* CNT<1>	CNT<1>
* CNT<2>	CNT<2>
* CNT<3>	CNT<3>
* CNT<4>	CNT<4>
* CNT<5>	CNT<5>
* CNT<6>	CNT<6>
* CNT<7>	CNT<7>
* CLK	CLK
mXI4.XI9.MM7 N_NET6<0>_XI4.XI9.MM7_d N_XI4.XI9.X_NOR_Y_XI4.XI9.MM7_g
+ N_VSS!_XI4.XI9.MM7_s N_VSS!_XI4.XI5.MM14_b nch L=1.8e-07 W=2e-06 AD=9.6e-13
+ AS=5.4e-13 PD=4.96e-06 PS=2.54e-06 NRD=0.24 NRS=0.135
mXI4.XI9.MM9 N_XI4.XI9.NET4_XI4.XI9.MM9_d N_CNT<7>_XI4.XI9.MM9_g
+ N_VSS!_XI4.XI9.MM9_s N_VSS!_XI4.XI5.MM14_b nch L=1.8e-07 W=2e-06 AD=5.4e-13
+ AS=5.4e-13 PD=2.54e-06 PS=2.54e-06 NRD=0.135 NRS=0.135
mXI4.XI9.MM8 N_NET6<0>_XI4.XI9.MM8_d N_XI4.NET72_XI4.XI9.MM8_g
+ N_XI4.XI9.NET4_XI4.XI9.MM8_s N_VSS!_XI4.XI5.MM14_b nch L=1.8e-07 W=2e-06
+ AD=9.6e-13 AS=5.4e-13 PD=4.96e-06 PS=2.54e-06 NRD=0.24 NRS=0.135
mXI4.XI9.MM5 N_XI4.XI9.X_NOR_Y_XI4.XI9.MM5_d N_XI4.NET72_XI4.XI9.MM5_g
+ N_VSS!_XI4.XI9.MM5_s N_VSS!_XI4.XI5.MM14_b nch L=1.8e-07 W=2e-06 AD=9.6e-13
+ AS=5.4e-13 PD=4.96e-06 PS=2.54e-06 NRD=0.24 NRS=0.135
mXI4.XI9.MM6 N_XI4.XI9.X_NOR_Y_XI4.XI9.MM6_d N_CNT<7>_XI4.XI9.MM6_g
+ N_VSS!_XI4.XI9.MM6_s N_VSS!_XI4.XI5.MM14_b nch L=1.8e-07 W=2e-06 AD=9.6e-13
+ AS=5.4e-13 PD=4.96e-06 PS=2.54e-06 NRD=0.24 NRS=0.135
mXI4.XI5.MM11 N_XI4.NET72_XI4.XI5.MM11_d N_XI4.XI5.X_NAND_Y_XI4.XI5.MM11_g
+ N_VSS!_XI4.XI5.MM11_s N_VSS!_XI4.XI5.MM14_b nch L=1.8e-07 W=2e-06 AD=9.6e-13
+ AS=9.6e-13 PD=4.96e-06 PS=4.96e-06 NRD=0.24 NRS=0.24
mXI5.MM1 N_CLK_B_XI5.MM1_d N_CLK_XI5.MM1_g N_VSS!_XI5.MM1_s
+ N_VSS!_XI4.XI5.MM14_b nch L=1.8e-07 W=2e-06 AD=9.6e-13 AS=9.6e-13 PD=4.96e-06
+ PS=4.96e-06 NRD=0.24 NRS=0.24
mXI4.XI5.MM7 N_XI4.XI5.NET075_XI4.XI5.MM7_d N_XI4.XI5.X_NAND_Y_XI4.XI5.MM7_g
+ N_XI4.XI5.NET7_XI4.XI5.MM7_s N_VSS!_XI4.XI5.MM14_b nch L=1.8e-07 W=2e-06
+ AD=9.6e-13 AS=5.4e-13 PD=4.96e-06 PS=2.54e-06 NRD=0.24 NRS=0.135
mXI4.XI4.MM7 N_XI4.XI4.NET075_XI4.XI4.MM7_d N_XI4.XI4.X_NAND_Y_XI4.XI4.MM7_g
+ N_XI4.XI4.NET7_XI4.XI4.MM7_s N_VSS!_XI4.XI5.MM14_b nch L=1.8e-07 W=2e-06
+ AD=9.6e-13 AS=5.4e-13 PD=4.96e-06 PS=2.54e-06 NRD=0.24 NRS=0.135
mXI4.XI3.MM7 N_XI4.XI3.NET075_XI4.XI3.MM7_d N_XI4.XI3.X_NAND_Y_XI4.XI3.MM7_g
+ N_XI4.XI3.NET7_XI4.XI3.MM7_s N_VSS!_XI4.XI5.MM14_b nch L=1.8e-07 W=2e-06
+ AD=9.6e-13 AS=5.4e-13 PD=4.96e-06 PS=2.54e-06 NRD=0.24 NRS=0.135
mXI4.XI2.MM7 N_XI4.XI2.NET075_XI4.XI2.MM7_d N_XI4.XI2.X_NAND_Y_XI4.XI2.MM7_g
+ N_XI4.XI2.NET7_XI4.XI2.MM7_s N_VSS!_XI4.XI5.MM14_b nch L=1.8e-07 W=2e-06
+ AD=9.6e-13 AS=5.4e-13 PD=4.96e-06 PS=2.54e-06 NRD=0.24 NRS=0.135
mXI4.XI1.MM7 N_XI4.XI1.NET075_XI4.XI1.MM7_d N_XI4.XI1.X_NAND_Y_XI4.XI1.MM7_g
+ N_XI4.XI1.NET7_XI4.XI1.MM7_s N_VSS!_XI4.XI5.MM14_b nch L=1.8e-07 W=2e-06
+ AD=9.6e-13 AS=5.4e-13 PD=4.96e-06 PS=2.54e-06 NRD=0.24 NRS=0.135
mXI4.XI0.MM7 N_XI4.XI0.NET075_XI4.XI0.MM7_d N_XI4.XI0.X_NAND_Y_XI4.XI0.MM7_g
+ N_XI4.XI0.NET7_XI4.XI0.MM7_s N_VSS!_XI4.XI5.MM14_b nch L=1.8e-07 W=2e-06
+ AD=9.6e-13 AS=5.4e-13 PD=4.96e-06 PS=2.54e-06 NRD=0.24 NRS=0.135
mXI4.XI5.MM9 N_XI4.XI5.NET7_XI4.XI5.MM9_d N_CNT<6>_XI4.XI5.MM9_g
+ N_VSS!_XI4.XI5.MM9_s N_VSS!_XI4.XI5.MM14_b nch L=1.8e-07 W=2e-06 AD=9.6e-13
+ AS=5.4e-13 PD=4.96e-06 PS=2.54e-06 NRD=0.24 NRS=0.135
mXI4.XI5.MM8 N_XI4.XI5.NET7_XI4.XI5.MM8_d N_XI4.NET77_XI4.XI5.MM8_g
+ N_VSS!_XI4.XI5.MM8_s N_VSS!_XI4.XI5.MM14_b nch L=1.8e-07 W=2e-06 AD=5.4e-13
+ AS=5.4e-13 PD=2.54e-06 PS=2.54e-06 NRD=0.135 NRS=0.135
mXI4.XI4.MM9 N_XI4.XI4.NET7_XI4.XI4.MM9_d N_CNT<5>_XI4.XI4.MM9_g
+ N_VSS!_XI4.XI4.MM9_s N_VSS!_XI4.XI5.MM14_b nch L=1.8e-07 W=2e-06 AD=9.6e-13
+ AS=5.4e-13 PD=4.96e-06 PS=2.54e-06 NRD=0.24 NRS=0.135
mXI4.XI4.MM8 N_XI4.XI4.NET7_XI4.XI4.MM8_d N_XI4.NET81_XI4.XI4.MM8_g
+ N_VSS!_XI4.XI4.MM8_s N_VSS!_XI4.XI5.MM14_b nch L=1.8e-07 W=2e-06 AD=5.4e-13
+ AS=5.4e-13 PD=2.54e-06 PS=2.54e-06 NRD=0.135 NRS=0.135
mXI4.XI3.MM9 N_XI4.XI3.NET7_XI4.XI3.MM9_d N_CNT<4>_XI4.XI3.MM9_g
+ N_VSS!_XI4.XI3.MM9_s N_VSS!_XI4.XI5.MM14_b nch L=1.8e-07 W=2e-06 AD=9.6e-13
+ AS=5.4e-13 PD=4.96e-06 PS=2.54e-06 NRD=0.24 NRS=0.135
mXI4.XI3.MM8 N_XI4.XI3.NET7_XI4.XI3.MM8_d N_XI4.NET85_XI4.XI3.MM8_g
+ N_VSS!_XI4.XI3.MM8_s N_VSS!_XI4.XI5.MM14_b nch L=1.8e-07 W=2e-06 AD=5.4e-13
+ AS=5.4e-13 PD=2.54e-06 PS=2.54e-06 NRD=0.135 NRS=0.135
mXI4.XI2.MM9 N_XI4.XI2.NET7_XI4.XI2.MM9_d N_CNT<3>_XI4.XI2.MM9_g
+ N_VSS!_XI4.XI2.MM9_s N_VSS!_XI4.XI5.MM14_b nch L=1.8e-07 W=2e-06 AD=9.6e-13
+ AS=5.4e-13 PD=4.96e-06 PS=2.54e-06 NRD=0.24 NRS=0.135
mXI4.XI2.MM8 N_XI4.XI2.NET7_XI4.XI2.MM8_d N_XI4.NET89_XI4.XI2.MM8_g
+ N_VSS!_XI4.XI2.MM8_s N_VSS!_XI4.XI5.MM14_b nch L=1.8e-07 W=2e-06 AD=5.4e-13
+ AS=5.4e-13 PD=2.54e-06 PS=2.54e-06 NRD=0.135 NRS=0.135
mXI4.XI1.MM9 N_XI4.XI1.NET7_XI4.XI1.MM9_d N_CNT<2>_XI4.XI1.MM9_g
+ N_VSS!_XI4.XI1.MM9_s N_VSS!_XI4.XI5.MM14_b nch L=1.8e-07 W=2e-06 AD=9.6e-13
+ AS=5.4e-13 PD=4.96e-06 PS=2.54e-06 NRD=0.24 NRS=0.135
mXI4.XI1.MM8 N_XI4.XI1.NET7_XI4.XI1.MM8_d N_XI4.NET93_XI4.XI1.MM8_g
+ N_VSS!_XI4.XI1.MM8_s N_VSS!_XI4.XI5.MM14_b nch L=1.8e-07 W=2e-06 AD=5.4e-13
+ AS=5.4e-13 PD=2.54e-06 PS=2.54e-06 NRD=0.135 NRS=0.135
mXI4.XI0.MM9 N_XI4.XI0.NET7_XI4.XI0.MM9_d N_CNT<1>_XI4.XI0.MM9_g
+ N_VSS!_XI4.XI0.MM9_s N_VSS!_XI4.XI5.MM14_b nch L=1.8e-07 W=2e-06 AD=9.6e-13
+ AS=5.4e-13 PD=4.96e-06 PS=2.54e-06 NRD=0.24 NRS=0.135
mXI4.XI0.MM8 N_XI4.XI0.NET7_XI4.XI0.MM8_d N_CNT<0>_XI4.XI0.MM8_g
+ N_VSS!_XI4.XI0.MM8_s N_VSS!_XI4.XI5.MM14_b nch L=1.8e-07 W=2e-06 AD=5.4e-13
+ AS=5.4e-13 PD=2.54e-06 PS=2.54e-06 NRD=0.135 NRS=0.135
mXI4.XI9.MM4 N_NET6<0>_XI4.XI9.MM4_d N_XI4.XI9.X_NOR_Y_XI4.XI9.MM4_g
+ N_XI4.XI9.NET24_XI4.XI9.MM4_s N_VDD!_XI4.XI5.MM13_b pch L=1.8e-07 W=4e-06
+ AD=1.92e-12 AS=1.08e-12 PD=8.96e-06 PS=4.54e-06 NRD=0.12 NRS=0.0675
mXI4.XI9.MM3 N_XI4.XI9.NET24_XI4.XI9.MM3_d N_CNT<7>_XI4.XI9.MM3_g
+ N_VDD!_XI4.XI9.MM3_s N_VDD!_XI4.XI5.MM13_b pch L=1.8e-07 W=4e-06 AD=1.08e-12
+ AS=1.08e-12 PD=4.54e-06 PS=4.54e-06 NRD=0.0675 NRS=0.0675
mXI4.XI9.MM2 N_XI4.XI9.NET24_XI4.XI9.MM2_d N_XI4.NET72_XI4.XI9.MM2_g
+ N_VDD!_XI4.XI9.MM2_s N_VDD!_XI4.XI5.MM13_b pch L=1.8e-07 W=4e-06 AD=1.92e-12
+ AS=1.08e-12 PD=8.96e-06 PS=4.54e-06 NRD=0.12 NRS=0.0675
mXI4.XI9.MM0 N_XI4.XI9.X_NOR_Y_XI4.XI9.MM0_d N_XI4.NET72_XI4.XI9.MM0_g
+ N_XI4.XI9.NET39_XI4.XI9.MM0_s N_VDD!_XI4.XI5.MM13_b pch L=1.8e-07 W=4e-06
+ AD=1.92e-12 AS=1.08e-12 PD=8.96e-06 PS=4.54e-06 NRD=0.12 NRS=0.0675
mXI4.XI9.MM1 N_XI4.XI9.NET39_XI4.XI9.MM1_d N_CNT<7>_XI4.XI9.MM1_g
+ N_VDD!_XI4.XI9.MM1_s N_VDD!_XI4.XI5.MM13_b pch L=1.8e-07 W=4e-06 AD=1.08e-12
+ AS=1.92e-12 PD=4.54e-06 PS=8.96e-06 NRD=0.0675 NRS=0.12
mXI4.XI5.MM12 N_XI4.NET72_XI4.XI5.MM12_d N_XI4.XI5.X_NAND_Y_XI4.XI5.MM12_g
+ N_VDD!_XI4.XI5.MM12_s N_VDD!_XI4.XI5.MM13_b pch L=1.8e-07 W=4e-06 AD=1.92e-12
+ AS=1.92e-12 PD=8.96e-06 PS=8.96e-06 NRD=0.12 NRS=0.12
mXI5.MM0 N_CLK_B_XI5.MM0_d N_CLK_XI5.MM0_g N_VDD!_XI5.MM0_s
+ N_VDD!_XI4.XI5.MM13_b pch L=1.8e-07 W=4e-06 AD=1.92e-12 AS=1.92e-12
+ PD=8.96e-06 PS=8.96e-06 NRD=0.12 NRS=0.12
mXI4.XI5.MM2 N_XI4.XI5.NET075_XI4.XI5.MM2_d N_XI4.XI5.X_NAND_Y_XI4.XI5.MM2_g
+ N_VDD!_XI4.XI5.MM2_s N_VDD!_XI4.XI5.MM13_b pch L=1.8e-07 W=4e-06 AD=1.92e-12
+ AS=1.08e-12 PD=8.96e-06 PS=4.54e-06 NRD=0.12 NRS=0.0675
mXI4.XI4.MM2 N_XI4.XI4.NET075_XI4.XI4.MM2_d N_XI4.XI4.X_NAND_Y_XI4.XI4.MM2_g
+ N_VDD!_XI4.XI4.MM2_s N_VDD!_XI4.XI5.MM13_b pch L=1.8e-07 W=4e-06 AD=1.92e-12
+ AS=1.08e-12 PD=8.96e-06 PS=4.54e-06 NRD=0.12 NRS=0.0675
mXI4.XI3.MM2 N_XI4.XI3.NET075_XI4.XI3.MM2_d N_XI4.XI3.X_NAND_Y_XI4.XI3.MM2_g
+ N_VDD!_XI4.XI3.MM2_s N_VDD!_XI4.XI5.MM13_b pch L=1.8e-07 W=4e-06 AD=1.92e-12
+ AS=1.08e-12 PD=8.96e-06 PS=4.54e-06 NRD=0.12 NRS=0.0675
mXI4.XI2.MM2 N_XI4.XI2.NET075_XI4.XI2.MM2_d N_XI4.XI2.X_NAND_Y_XI4.XI2.MM2_g
+ N_VDD!_XI4.XI2.MM2_s N_VDD!_XI4.XI5.MM13_b pch L=1.8e-07 W=4e-06 AD=1.92e-12
+ AS=1.08e-12 PD=8.96e-06 PS=4.54e-06 NRD=0.12 NRS=0.0675
mXI4.XI1.MM2 N_XI4.XI1.NET075_XI4.XI1.MM2_d N_XI4.XI1.X_NAND_Y_XI4.XI1.MM2_g
+ N_VDD!_XI4.XI1.MM2_s N_VDD!_XI4.XI5.MM13_b pch L=1.8e-07 W=4e-06 AD=1.92e-12
+ AS=1.08e-12 PD=8.96e-06 PS=4.54e-06 NRD=0.12 NRS=0.0675
mXI4.XI0.MM2 N_XI4.XI0.NET075_XI4.XI0.MM2_d N_XI4.XI0.X_NAND_Y_XI4.XI0.MM2_g
+ N_VDD!_XI4.XI0.MM2_s N_VDD!_XI4.XI5.MM13_b pch L=1.8e-07 W=4e-06 AD=1.92e-12
+ AS=1.08e-12 PD=8.96e-06 PS=4.54e-06 NRD=0.12 NRS=0.0675
mXI4.XI5.MM3 N_XI4.XI5.NET075_XI4.XI5.MM3_d N_CNT<6>_XI4.XI5.MM3_g
+ N_XI4.XI5.NET30_XI4.XI5.MM3_s N_VDD!_XI4.XI5.MM13_b pch L=1.8e-07 W=4e-06
+ AD=1.92e-12 AS=1.08e-12 PD=8.96e-06 PS=4.54e-06 NRD=0.12 NRS=0.0675
mXI4.XI5.MM4 N_XI4.XI5.NET30_XI4.XI5.MM4_d N_XI4.NET77_XI4.XI5.MM4_g
+ N_VDD!_XI4.XI5.MM4_s N_VDD!_XI4.XI5.MM13_b pch L=1.8e-07 W=4e-06 AD=1.08e-12
+ AS=1.08e-12 PD=4.54e-06 PS=4.54e-06 NRD=0.0675 NRS=0.0675
mXI4.XI4.MM3 N_XI4.XI4.NET075_XI4.XI4.MM3_d N_CNT<5>_XI4.XI4.MM3_g
+ N_XI4.XI4.NET30_XI4.XI4.MM3_s N_VDD!_XI4.XI5.MM13_b pch L=1.8e-07 W=4e-06
+ AD=1.92e-12 AS=1.08e-12 PD=8.96e-06 PS=4.54e-06 NRD=0.12 NRS=0.0675
mXI4.XI4.MM4 N_XI4.XI4.NET30_XI4.XI4.MM4_d N_XI4.NET81_XI4.XI4.MM4_g
+ N_VDD!_XI4.XI4.MM4_s N_VDD!_XI4.XI5.MM13_b pch L=1.8e-07 W=4e-06 AD=1.08e-12
+ AS=1.08e-12 PD=4.54e-06 PS=4.54e-06 NRD=0.0675 NRS=0.0675
mXI4.XI3.MM3 N_XI4.XI3.NET075_XI4.XI3.MM3_d N_CNT<4>_XI4.XI3.MM3_g
+ N_XI4.XI3.NET30_XI4.XI3.MM3_s N_VDD!_XI4.XI5.MM13_b pch L=1.8e-07 W=4e-06
+ AD=1.92e-12 AS=1.08e-12 PD=8.96e-06 PS=4.54e-06 NRD=0.12 NRS=0.0675
mXI4.XI3.MM4 N_XI4.XI3.NET30_XI4.XI3.MM4_d N_XI4.NET85_XI4.XI3.MM4_g
+ N_VDD!_XI4.XI3.MM4_s N_VDD!_XI4.XI5.MM13_b pch L=1.8e-07 W=4e-06 AD=1.08e-12
+ AS=1.08e-12 PD=4.54e-06 PS=4.54e-06 NRD=0.0675 NRS=0.0675
mXI4.XI2.MM3 N_XI4.XI2.NET075_XI4.XI2.MM3_d N_CNT<3>_XI4.XI2.MM3_g
+ N_XI4.XI2.NET30_XI4.XI2.MM3_s N_VDD!_XI4.XI5.MM13_b pch L=1.8e-07 W=4e-06
+ AD=1.92e-12 AS=1.08e-12 PD=8.96e-06 PS=4.54e-06 NRD=0.12 NRS=0.0675
mXI4.XI2.MM4 N_XI4.XI2.NET30_XI4.XI2.MM4_d N_XI4.NET89_XI4.XI2.MM4_g
+ N_VDD!_XI4.XI2.MM4_s N_VDD!_XI4.XI5.MM13_b pch L=1.8e-07 W=4e-06 AD=1.08e-12
+ AS=1.08e-12 PD=4.54e-06 PS=4.54e-06 NRD=0.0675 NRS=0.0675
mXI4.XI1.MM3 N_XI4.XI1.NET075_XI4.XI1.MM3_d N_CNT<2>_XI4.XI1.MM3_g
+ N_XI4.XI1.NET30_XI4.XI1.MM3_s N_VDD!_XI4.XI5.MM13_b pch L=1.8e-07 W=4e-06
+ AD=1.92e-12 AS=1.08e-12 PD=8.96e-06 PS=4.54e-06 NRD=0.12 NRS=0.0675
mXI4.XI1.MM4 N_XI4.XI1.NET30_XI4.XI1.MM4_d N_XI4.NET93_XI4.XI1.MM4_g
+ N_VDD!_XI4.XI1.MM4_s N_VDD!_XI4.XI5.MM13_b pch L=1.8e-07 W=4e-06 AD=1.08e-12
+ AS=1.08e-12 PD=4.54e-06 PS=4.54e-06 NRD=0.0675 NRS=0.0675
mXI4.XI0.MM3 N_XI4.XI0.NET075_XI4.XI0.MM3_d N_CNT<1>_XI4.XI0.MM3_g
+ N_XI4.XI0.NET30_XI4.XI0.MM3_s N_VDD!_XI4.XI5.MM13_b pch L=1.8e-07 W=4e-06
+ AD=1.92e-12 AS=1.08e-12 PD=8.96e-06 PS=4.54e-06 NRD=0.12 NRS=0.0675
mXI4.XI0.MM4 N_XI4.XI0.NET30_XI4.XI0.MM4_d N_CNT<0>_XI4.XI0.MM4_g
+ N_VDD!_XI4.XI0.MM4_s N_VDD!_XI4.XI5.MM13_b pch L=1.8e-07 W=4e-06 AD=1.08e-12
+ AS=1.08e-12 PD=4.54e-06 PS=4.54e-06 NRD=0.0675 NRS=0.0675
mXI4.XI5.MM14 N_NET6<1>_XI4.XI5.MM14_d N_XI4.XI5.NET075_XI4.XI5.MM14_g
+ N_VSS!_XI4.XI5.MM14_s N_VSS!_XI4.XI5.MM14_b nch L=1.8e-07 W=2e-06 AD=9.6e-13
+ AS=9.6e-13 PD=4.96e-06 PS=4.96e-06 NRD=0.24 NRS=0.24
mXI4.XI4.MM11 N_XI4.NET77_XI4.XI4.MM11_d N_XI4.XI4.X_NAND_Y_XI4.XI4.MM11_g
+ N_VSS!_XI4.XI4.MM11_s N_VSS!_XI4.XI5.MM14_b nch L=1.8e-07 W=2e-06 AD=9.6e-13
+ AS=9.6e-13 PD=4.96e-06 PS=4.96e-06 NRD=0.24 NRS=0.24
mXI4.XI5.MM13 N_NET6<1>_XI4.XI5.MM13_d N_XI4.XI5.NET075_XI4.XI5.MM13_g
+ N_VDD!_XI4.XI5.MM13_s N_VDD!_XI4.XI5.MM13_b pch L=1.8e-07 W=4e-06 AD=1.92e-12
+ AS=1.92e-12 PD=8.96e-06 PS=8.96e-06 NRD=0.12 NRS=0.12
mXI4.XI4.MM12 N_XI4.NET77_XI4.XI4.MM12_d N_XI4.XI4.X_NAND_Y_XI4.XI4.MM12_g
+ N_VDD!_XI4.XI4.MM12_s N_VDD!_XI4.XI5.MM13_b pch L=1.8e-07 W=4e-06 AD=1.92e-12
+ AS=1.92e-12 PD=8.96e-06 PS=8.96e-06 NRD=0.12 NRS=0.12
mXI4.XI4.MM14 N_NET6<2>_XI4.XI4.MM14_d N_XI4.XI4.NET075_XI4.XI4.MM14_g
+ N_VSS!_XI4.XI4.MM14_s N_VSS!_XI4.XI5.MM14_b nch L=1.8e-07 W=2e-06 AD=9.6e-13
+ AS=9.6e-13 PD=4.96e-06 PS=4.96e-06 NRD=0.24 NRS=0.24
mXI4.XI3.MM11 N_XI4.NET81_XI4.XI3.MM11_d N_XI4.XI3.X_NAND_Y_XI4.XI3.MM11_g
+ N_VSS!_XI4.XI3.MM11_s N_VSS!_XI4.XI5.MM14_b nch L=1.8e-07 W=2e-06 AD=9.6e-13
+ AS=9.6e-13 PD=4.96e-06 PS=4.96e-06 NRD=0.24 NRS=0.24
mXI4.XI4.MM13 N_NET6<2>_XI4.XI4.MM13_d N_XI4.XI4.NET075_XI4.XI4.MM13_g
+ N_VDD!_XI4.XI4.MM13_s N_VDD!_XI4.XI5.MM13_b pch L=1.8e-07 W=4e-06 AD=1.92e-12
+ AS=1.92e-12 PD=8.96e-06 PS=8.96e-06 NRD=0.12 NRS=0.12
mXI4.XI3.MM12 N_XI4.NET81_XI4.XI3.MM12_d N_XI4.XI3.X_NAND_Y_XI4.XI3.MM12_g
+ N_VDD!_XI4.XI3.MM12_s N_VDD!_XI4.XI5.MM13_b pch L=1.8e-07 W=4e-06 AD=1.92e-12
+ AS=1.92e-12 PD=8.96e-06 PS=8.96e-06 NRD=0.12 NRS=0.12
mXI4.XI3.MM14 N_NET6<3>_XI4.XI3.MM14_d N_XI4.XI3.NET075_XI4.XI3.MM14_g
+ N_VSS!_XI4.XI3.MM14_s N_VSS!_XI4.XI5.MM14_b nch L=1.8e-07 W=2e-06 AD=9.6e-13
+ AS=9.6e-13 PD=4.96e-06 PS=4.96e-06 NRD=0.24 NRS=0.24
mXI4.XI2.MM11 N_XI4.NET85_XI4.XI2.MM11_d N_XI4.XI2.X_NAND_Y_XI4.XI2.MM11_g
+ N_VSS!_XI4.XI2.MM11_s N_VSS!_XI4.XI5.MM14_b nch L=1.8e-07 W=2e-06 AD=9.6e-13
+ AS=9.6e-13 PD=4.96e-06 PS=4.96e-06 NRD=0.24 NRS=0.24
mXI4.XI3.MM13 N_NET6<3>_XI4.XI3.MM13_d N_XI4.XI3.NET075_XI4.XI3.MM13_g
+ N_VDD!_XI4.XI3.MM13_s N_VDD!_XI4.XI5.MM13_b pch L=1.8e-07 W=4e-06 AD=1.92e-12
+ AS=1.92e-12 PD=8.96e-06 PS=8.96e-06 NRD=0.12 NRS=0.12
mXI4.XI2.MM12 N_XI4.NET85_XI4.XI2.MM12_d N_XI4.XI2.X_NAND_Y_XI4.XI2.MM12_g
+ N_VDD!_XI4.XI2.MM12_s N_VDD!_XI4.XI5.MM13_b pch L=1.8e-07 W=4e-06 AD=1.92e-12
+ AS=1.92e-12 PD=8.96e-06 PS=8.96e-06 NRD=0.12 NRS=0.12
mXI4.XI2.MM14 N_NET6<4>_XI4.XI2.MM14_d N_XI4.XI2.NET075_XI4.XI2.MM14_g
+ N_VSS!_XI4.XI2.MM14_s N_VSS!_XI4.XI5.MM14_b nch L=1.8e-07 W=2e-06 AD=9.6e-13
+ AS=9.6e-13 PD=4.96e-06 PS=4.96e-06 NRD=0.24 NRS=0.24
mXI4.XI1.MM11 N_XI4.NET89_XI4.XI1.MM11_d N_XI4.XI1.X_NAND_Y_XI4.XI1.MM11_g
+ N_VSS!_XI4.XI1.MM11_s N_VSS!_XI4.XI5.MM14_b nch L=1.8e-07 W=2e-06 AD=9.6e-13
+ AS=9.6e-13 PD=4.96e-06 PS=4.96e-06 NRD=0.24 NRS=0.24
mXI4.XI2.MM13 N_NET6<4>_XI4.XI2.MM13_d N_XI4.XI2.NET075_XI4.XI2.MM13_g
+ N_VDD!_XI4.XI2.MM13_s N_VDD!_XI4.XI5.MM13_b pch L=1.8e-07 W=4e-06 AD=1.92e-12
+ AS=1.92e-12 PD=8.96e-06 PS=8.96e-06 NRD=0.12 NRS=0.12
mXI4.XI1.MM12 N_XI4.NET89_XI4.XI1.MM12_d N_XI4.XI1.X_NAND_Y_XI4.XI1.MM12_g
+ N_VDD!_XI4.XI1.MM12_s N_VDD!_XI4.XI5.MM13_b pch L=1.8e-07 W=4e-06 AD=1.92e-12
+ AS=1.92e-12 PD=8.96e-06 PS=8.96e-06 NRD=0.12 NRS=0.12
mXI4.XI1.MM14 N_NET6<5>_XI4.XI1.MM14_d N_XI4.XI1.NET075_XI4.XI1.MM14_g
+ N_VSS!_XI4.XI1.MM14_s N_VSS!_XI4.XI5.MM14_b nch L=1.8e-07 W=2e-06 AD=9.6e-13
+ AS=9.6e-13 PD=4.96e-06 PS=4.96e-06 NRD=0.24 NRS=0.24
mXI4.XI0.MM11 N_XI4.NET93_XI4.XI0.MM11_d N_XI4.XI0.X_NAND_Y_XI4.XI0.MM11_g
+ N_VSS!_XI4.XI0.MM11_s N_VSS!_XI4.XI5.MM14_b nch L=1.8e-07 W=2e-06 AD=9.6e-13
+ AS=9.6e-13 PD=4.96e-06 PS=4.96e-06 NRD=0.24 NRS=0.24
mXI4.XI1.MM13 N_NET6<5>_XI4.XI1.MM13_d N_XI4.XI1.NET075_XI4.XI1.MM13_g
+ N_VDD!_XI4.XI1.MM13_s N_VDD!_XI4.XI5.MM13_b pch L=1.8e-07 W=4e-06 AD=1.92e-12
+ AS=1.92e-12 PD=8.96e-06 PS=8.96e-06 NRD=0.12 NRS=0.12
mXI4.XI0.MM12 N_XI4.NET93_XI4.XI0.MM12_d N_XI4.XI0.X_NAND_Y_XI4.XI0.MM12_g
+ N_VDD!_XI4.XI0.MM12_s N_VDD!_XI4.XI5.MM13_b pch L=1.8e-07 W=4e-06 AD=1.92e-12
+ AS=1.92e-12 PD=8.96e-06 PS=8.96e-06 NRD=0.12 NRS=0.12
mXI4.XI0.MM14 N_NET6<6>_XI4.XI0.MM14_d N_XI4.XI0.NET075_XI4.XI0.MM14_g
+ N_VSS!_XI4.XI0.MM14_s N_VSS!_XI4.XI5.MM14_b nch L=1.8e-07 W=2e-06 AD=9.6e-13
+ AS=9.6e-13 PD=4.96e-06 PS=4.96e-06 NRD=0.24 NRS=0.24
mXI4.XI8.MM1 N_NET6<7>_XI4.XI8.MM1_d N_CNT<0>_XI4.XI8.MM1_g N_VSS!_XI4.XI8.MM1_s
+ N_VSS!_XI4.XI5.MM14_b nch L=1.8e-07 W=2e-06 AD=9.6e-13 AS=9.6e-13 PD=4.96e-06
+ PS=4.96e-06 NRD=0.24 NRS=0.24
mXI4.XI0.MM13 N_NET6<6>_XI4.XI0.MM13_d N_XI4.XI0.NET075_XI4.XI0.MM13_g
+ N_VDD!_XI4.XI0.MM13_s N_VDD!_XI4.XI5.MM13_b pch L=1.8e-07 W=4e-06 AD=1.92e-12
+ AS=1.92e-12 PD=8.96e-06 PS=8.96e-06 NRD=0.12 NRS=0.12
mXI4.XI8.MM0 N_NET6<7>_XI4.XI8.MM0_d N_CNT<0>_XI4.XI8.MM0_g N_VDD!_XI4.XI8.MM0_s
+ N_VDD!_XI4.XI5.MM13_b pch L=1.8e-07 W=4e-06 AD=1.92e-12 AS=1.92e-12
+ PD=8.96e-06 PS=8.96e-06 NRD=0.12 NRS=0.12
mXI4.XI5.MM6 N_XI4.XI5.NET15_XI4.XI5.MM6_d N_CNT<6>_XI4.XI5.MM6_g
+ N_VSS!_XI4.XI5.MM6_s N_VSS!_XI4.XI5.MM14_b nch L=1.8e-07 W=2e-06 AD=5.4e-13
+ AS=9.6e-13 PD=2.54e-06 PS=4.96e-06 NRD=0.135 NRS=0.24
mXI4.XI5.MM5 N_XI4.XI5.X_NAND_Y_XI4.XI5.MM5_d N_XI4.NET77_XI4.XI5.MM5_g
+ N_XI4.XI5.NET15_XI4.XI5.MM5_s N_VSS!_XI4.XI5.MM14_b nch L=1.8e-07 W=2e-06
+ AD=9.6e-13 AS=5.4e-13 PD=4.96e-06 PS=2.54e-06 NRD=0.24 NRS=0.135
mXI4.XI4.MM6 N_XI4.XI4.NET15_XI4.XI4.MM6_d N_CNT<5>_XI4.XI4.MM6_g
+ N_VSS!_XI4.XI4.MM6_s N_VSS!_XI4.XI5.MM14_b nch L=1.8e-07 W=2e-06 AD=5.4e-13
+ AS=9.6e-13 PD=2.54e-06 PS=4.96e-06 NRD=0.135 NRS=0.24
mXI4.XI4.MM5 N_XI4.XI4.X_NAND_Y_XI4.XI4.MM5_d N_XI4.NET81_XI4.XI4.MM5_g
+ N_XI4.XI4.NET15_XI4.XI4.MM5_s N_VSS!_XI4.XI5.MM14_b nch L=1.8e-07 W=2e-06
+ AD=9.6e-13 AS=5.4e-13 PD=4.96e-06 PS=2.54e-06 NRD=0.24 NRS=0.135
mXI4.XI3.MM6 N_XI4.XI3.NET15_XI4.XI3.MM6_d N_CNT<4>_XI4.XI3.MM6_g
+ N_VSS!_XI4.XI3.MM6_s N_VSS!_XI4.XI5.MM14_b nch L=1.8e-07 W=2e-06 AD=5.4e-13
+ AS=9.6e-13 PD=2.54e-06 PS=4.96e-06 NRD=0.135 NRS=0.24
mXI4.XI3.MM5 N_XI4.XI3.X_NAND_Y_XI4.XI3.MM5_d N_XI4.NET85_XI4.XI3.MM5_g
+ N_XI4.XI3.NET15_XI4.XI3.MM5_s N_VSS!_XI4.XI5.MM14_b nch L=1.8e-07 W=2e-06
+ AD=9.6e-13 AS=5.4e-13 PD=4.96e-06 PS=2.54e-06 NRD=0.24 NRS=0.135
mXI4.XI2.MM6 N_XI4.XI2.NET15_XI4.XI2.MM6_d N_CNT<3>_XI4.XI2.MM6_g
+ N_VSS!_XI4.XI2.MM6_s N_VSS!_XI4.XI5.MM14_b nch L=1.8e-07 W=2e-06 AD=5.4e-13
+ AS=9.6e-13 PD=2.54e-06 PS=4.96e-06 NRD=0.135 NRS=0.24
mXI4.XI2.MM5 N_XI4.XI2.X_NAND_Y_XI4.XI2.MM5_d N_XI4.NET89_XI4.XI2.MM5_g
+ N_XI4.XI2.NET15_XI4.XI2.MM5_s N_VSS!_XI4.XI5.MM14_b nch L=1.8e-07 W=2e-06
+ AD=9.6e-13 AS=5.4e-13 PD=4.96e-06 PS=2.54e-06 NRD=0.24 NRS=0.135
mXI4.XI1.MM6 N_XI4.XI1.NET15_XI4.XI1.MM6_d N_CNT<2>_XI4.XI1.MM6_g
+ N_VSS!_XI4.XI1.MM6_s N_VSS!_XI4.XI5.MM14_b nch L=1.8e-07 W=2e-06 AD=5.4e-13
+ AS=9.6e-13 PD=2.54e-06 PS=4.96e-06 NRD=0.135 NRS=0.24
mXI4.XI1.MM5 N_XI4.XI1.X_NAND_Y_XI4.XI1.MM5_d N_XI4.NET93_XI4.XI1.MM5_g
+ N_XI4.XI1.NET15_XI4.XI1.MM5_s N_VSS!_XI4.XI5.MM14_b nch L=1.8e-07 W=2e-06
+ AD=9.6e-13 AS=5.4e-13 PD=4.96e-06 PS=2.54e-06 NRD=0.24 NRS=0.135
mXI4.XI0.MM6 N_XI4.XI0.NET15_XI4.XI0.MM6_d N_CNT<1>_XI4.XI0.MM6_g
+ N_VSS!_XI4.XI0.MM6_s N_VSS!_XI4.XI5.MM14_b nch L=1.8e-07 W=2e-06 AD=5.4e-13
+ AS=9.6e-13 PD=2.54e-06 PS=4.96e-06 NRD=0.135 NRS=0.24
mXI4.XI0.MM5 N_XI4.XI0.X_NAND_Y_XI4.XI0.MM5_d N_CNT<0>_XI4.XI0.MM5_g
+ N_XI4.XI0.NET15_XI4.XI0.MM5_s N_VSS!_XI4.XI5.MM14_b nch L=1.8e-07 W=2e-06
+ AD=9.6e-13 AS=5.4e-13 PD=4.96e-06 PS=2.54e-06 NRD=0.24 NRS=0.135
mXI4.XI5.MM1 N_XI4.XI5.X_NAND_Y_XI4.XI5.MM1_d N_CNT<6>_XI4.XI5.MM1_g
+ N_VDD!_XI4.XI5.MM1_s N_VDD!_XI4.XI5.MM13_b pch L=1.8e-07 W=4e-06 AD=1.92e-12
+ AS=1.08e-12 PD=8.96e-06 PS=4.54e-06 NRD=0.12 NRS=0.0675
mXI4.XI5.MM0 N_XI4.XI5.X_NAND_Y_XI4.XI5.MM0_d N_XI4.NET77_XI4.XI5.MM0_g
+ N_VDD!_XI4.XI5.MM0_s N_VDD!_XI4.XI5.MM13_b pch L=1.8e-07 W=4e-06 AD=1.92e-12
+ AS=1.08e-12 PD=8.96e-06 PS=4.54e-06 NRD=0.12 NRS=0.0675
mXI4.XI4.MM1 N_XI4.XI4.X_NAND_Y_XI4.XI4.MM1_d N_CNT<5>_XI4.XI4.MM1_g
+ N_VDD!_XI4.XI4.MM1_s N_VDD!_XI4.XI5.MM13_b pch L=1.8e-07 W=4e-06 AD=1.92e-12
+ AS=1.08e-12 PD=8.96e-06 PS=4.54e-06 NRD=0.12 NRS=0.0675
mXI4.XI4.MM0 N_XI4.XI4.X_NAND_Y_XI4.XI4.MM0_d N_XI4.NET81_XI4.XI4.MM0_g
+ N_VDD!_XI4.XI4.MM0_s N_VDD!_XI4.XI5.MM13_b pch L=1.8e-07 W=4e-06 AD=1.92e-12
+ AS=1.08e-12 PD=8.96e-06 PS=4.54e-06 NRD=0.12 NRS=0.0675
mXI4.XI3.MM1 N_XI4.XI3.X_NAND_Y_XI4.XI3.MM1_d N_CNT<4>_XI4.XI3.MM1_g
+ N_VDD!_XI4.XI3.MM1_s N_VDD!_XI4.XI5.MM13_b pch L=1.8e-07 W=4e-06 AD=1.92e-12
+ AS=1.08e-12 PD=8.96e-06 PS=4.54e-06 NRD=0.12 NRS=0.0675
mXI4.XI3.MM0 N_XI4.XI3.X_NAND_Y_XI4.XI3.MM0_d N_XI4.NET85_XI4.XI3.MM0_g
+ N_VDD!_XI4.XI3.MM0_s N_VDD!_XI4.XI5.MM13_b pch L=1.8e-07 W=4e-06 AD=1.92e-12
+ AS=1.08e-12 PD=8.96e-06 PS=4.54e-06 NRD=0.12 NRS=0.0675
mXI4.XI2.MM1 N_XI4.XI2.X_NAND_Y_XI4.XI2.MM1_d N_CNT<3>_XI4.XI2.MM1_g
+ N_VDD!_XI4.XI2.MM1_s N_VDD!_XI4.XI5.MM13_b pch L=1.8e-07 W=4e-06 AD=1.92e-12
+ AS=1.08e-12 PD=8.96e-06 PS=4.54e-06 NRD=0.12 NRS=0.0675
mXI4.XI2.MM0 N_XI4.XI2.X_NAND_Y_XI4.XI2.MM0_d N_XI4.NET89_XI4.XI2.MM0_g
+ N_VDD!_XI4.XI2.MM0_s N_VDD!_XI4.XI5.MM13_b pch L=1.8e-07 W=4e-06 AD=1.92e-12
+ AS=1.08e-12 PD=8.96e-06 PS=4.54e-06 NRD=0.12 NRS=0.0675
mXI4.XI1.MM1 N_XI4.XI1.X_NAND_Y_XI4.XI1.MM1_d N_CNT<2>_XI4.XI1.MM1_g
+ N_VDD!_XI4.XI1.MM1_s N_VDD!_XI4.XI5.MM13_b pch L=1.8e-07 W=4e-06 AD=1.92e-12
+ AS=1.08e-12 PD=8.96e-06 PS=4.54e-06 NRD=0.12 NRS=0.0675
mXI4.XI1.MM0 N_XI4.XI1.X_NAND_Y_XI4.XI1.MM0_d N_XI4.NET93_XI4.XI1.MM0_g
+ N_VDD!_XI4.XI1.MM0_s N_VDD!_XI4.XI5.MM13_b pch L=1.8e-07 W=4e-06 AD=1.92e-12
+ AS=1.08e-12 PD=8.96e-06 PS=4.54e-06 NRD=0.12 NRS=0.0675
mXI4.XI0.MM1 N_XI4.XI0.X_NAND_Y_XI4.XI0.MM1_d N_CNT<1>_XI4.XI0.MM1_g
+ N_VDD!_XI4.XI0.MM1_s N_VDD!_XI4.XI5.MM13_b pch L=1.8e-07 W=4e-06 AD=1.92e-12
+ AS=1.08e-12 PD=8.96e-06 PS=4.54e-06 NRD=0.12 NRS=0.0675
mXI4.XI0.MM0 N_XI4.XI0.X_NAND_Y_XI4.XI0.MM0_d N_CNT<0>_XI4.XI0.MM0_g
+ N_VDD!_XI4.XI0.MM0_s N_VDD!_XI4.XI5.MM13_b pch L=1.8e-07 W=4e-06 AD=1.92e-12
+ AS=1.08e-12 PD=8.96e-06 PS=4.54e-06 NRD=0.12 NRS=0.0675
mXI3.XI0.MM10 N_XI3.XI0.NET40_XI3.XI0.MM10_d N_CLK_XI3.XI0.MM10_g
+ N_XI3.XI0.NET39_XI3.XI0.MM10_s N_VSS!_XI4.XI5.MM14_b nch L=1.8e-07 W=2e-06
+ AD=9.6e-13 AS=5.4e-13 PD=4.96e-06 PS=2.54e-06 NRD=0.24 NRS=0.135
mXI3.XI0.MM14 N_XI3.XI0.NET24_XI3.XI0.MM14_d N_CLK_B_XI3.XI0.MM14_g
+ N_XI3.XI0.NET39_XI3.XI0.MM14_s N_VSS!_XI4.XI5.MM14_b nch L=1.8e-07 W=2e-06
+ AD=5.4e-13 AS=5.4e-13 PD=2.54e-06 PS=2.54e-06 NRD=0.135 NRS=0.135
mXI3.XI0.MM13 N_XI3.XI0.NET24_XI3.XI0.MM13_d N_CNT<7>_XI3.XI0.MM13_g
+ N_VSS!_XI3.XI0.MM13_s N_VSS!_XI4.XI5.MM14_b nch L=1.8e-07 W=2e-06 AD=5.4e-13
+ AS=5.4e-13 PD=2.54e-06 PS=2.54e-06 NRD=0.135 NRS=0.135
mXI3.XI0.MM12 N_CNT<7>_XI3.XI0.MM12_d N_XI3.XI0.NET39_XI3.XI0.MM12_g
+ N_VSS!_XI3.XI0.MM12_s N_VSS!_XI4.XI5.MM14_b nch L=1.8e-07 W=2e-06 AD=9.6e-13
+ AS=5.4e-13 PD=4.96e-06 PS=2.54e-06 NRD=0.24 NRS=0.135
mXI3.XI0.MM2 N_XI3.XI0.NET40_XI3.XI0.MM2_d N_XI3.XI0.NET23_XI3.XI0.MM2_g
+ N_VSS!_XI3.XI0.MM2_s N_VSS!_XI4.XI5.MM14_b nch L=1.8e-07 W=2e-06 AD=9.6e-13
+ AS=5.4e-13 PD=4.96e-06 PS=2.54e-06 NRD=0.24 NRS=0.135
mXI3.XI0.MM6 N_XI3.XI0.NET48_XI3.XI0.MM6_d N_XI3.XI0.NET40_XI3.XI0.MM6_g
+ N_VSS!_XI3.XI0.MM6_s N_VSS!_XI4.XI5.MM14_b nch L=1.8e-07 W=2e-06 AD=9.6e-13
+ AS=5.4e-13 PD=4.96e-06 PS=2.54e-06 NRD=0.24 NRS=0.135
mXI3.XI0.MM1 N_NET6<0>_XI3.XI0.MM1_d N_CLK_B_XI3.XI0.MM1_g
+ N_XI3.XI0.NET23_XI3.XI0.MM1_s N_VSS!_XI4.XI5.MM14_b nch L=1.8e-07 W=2e-06
+ AD=9.6e-13 AS=5.4e-13 PD=4.96e-06 PS=2.54e-06 NRD=0.24 NRS=0.135
mXI3.XI0.MM8 N_XI3.XI0.NET48_XI3.XI0.MM8_d N_CLK_XI3.XI0.MM8_g
+ N_XI3.XI0.NET23_XI3.XI0.MM8_s N_VSS!_XI4.XI5.MM14_b nch L=1.8e-07 W=2e-06
+ AD=9.6e-13 AS=5.4e-13 PD=4.96e-06 PS=2.54e-06 NRD=0.24 NRS=0.135
mXI3.XI1.MM10 N_XI3.XI1.NET40_XI3.XI1.MM10_d N_CLK_XI3.XI1.MM10_g
+ N_XI3.XI1.NET39_XI3.XI1.MM10_s N_VSS!_XI4.XI5.MM14_b nch L=1.8e-07 W=2e-06
+ AD=9.6e-13 AS=5.4e-13 PD=4.96e-06 PS=2.54e-06 NRD=0.24 NRS=0.135
mXI3.XI1.MM14 N_XI3.XI1.NET24_XI3.XI1.MM14_d N_CLK_B_XI3.XI1.MM14_g
+ N_XI3.XI1.NET39_XI3.XI1.MM14_s N_VSS!_XI4.XI5.MM14_b nch L=1.8e-07 W=2e-06
+ AD=5.4e-13 AS=5.4e-13 PD=2.54e-06 PS=2.54e-06 NRD=0.135 NRS=0.135
mXI3.XI1.MM13 N_XI3.XI1.NET24_XI3.XI1.MM13_d N_CNT<6>_XI3.XI1.MM13_g
+ N_VSS!_XI3.XI1.MM13_s N_VSS!_XI4.XI5.MM14_b nch L=1.8e-07 W=2e-06 AD=5.4e-13
+ AS=5.4e-13 PD=2.54e-06 PS=2.54e-06 NRD=0.135 NRS=0.135
mXI3.XI1.MM12 N_CNT<6>_XI3.XI1.MM12_d N_XI3.XI1.NET39_XI3.XI1.MM12_g
+ N_VSS!_XI3.XI1.MM12_s N_VSS!_XI4.XI5.MM14_b nch L=1.8e-07 W=2e-06 AD=9.6e-13
+ AS=5.4e-13 PD=4.96e-06 PS=2.54e-06 NRD=0.24 NRS=0.135
mXI3.XI1.MM2 N_XI3.XI1.NET40_XI3.XI1.MM2_d N_XI3.XI1.NET23_XI3.XI1.MM2_g
+ N_VSS!_XI3.XI1.MM2_s N_VSS!_XI4.XI5.MM14_b nch L=1.8e-07 W=2e-06 AD=9.6e-13
+ AS=5.4e-13 PD=4.96e-06 PS=2.54e-06 NRD=0.24 NRS=0.135
mXI3.XI1.MM6 N_XI3.XI1.NET48_XI3.XI1.MM6_d N_XI3.XI1.NET40_XI3.XI1.MM6_g
+ N_VSS!_XI3.XI1.MM6_s N_VSS!_XI4.XI5.MM14_b nch L=1.8e-07 W=2e-06 AD=9.6e-13
+ AS=5.4e-13 PD=4.96e-06 PS=2.54e-06 NRD=0.24 NRS=0.135
mXI3.XI1.MM1 N_NET6<1>_XI3.XI1.MM1_d N_CLK_B_XI3.XI1.MM1_g
+ N_XI3.XI1.NET23_XI3.XI1.MM1_s N_VSS!_XI4.XI5.MM14_b nch L=1.8e-07 W=2e-06
+ AD=9.6e-13 AS=5.4e-13 PD=4.96e-06 PS=2.54e-06 NRD=0.24 NRS=0.135
mXI3.XI1.MM8 N_XI3.XI1.NET48_XI3.XI1.MM8_d N_CLK_XI3.XI1.MM8_g
+ N_XI3.XI1.NET23_XI3.XI1.MM8_s N_VSS!_XI4.XI5.MM14_b nch L=1.8e-07 W=2e-06
+ AD=9.6e-13 AS=5.4e-13 PD=4.96e-06 PS=2.54e-06 NRD=0.24 NRS=0.135
mXI3.XI2.MM10 N_XI3.XI2.NET40_XI3.XI2.MM10_d N_CLK_XI3.XI2.MM10_g
+ N_XI3.XI2.NET39_XI3.XI2.MM10_s N_VSS!_XI4.XI5.MM14_b nch L=1.8e-07 W=2e-06
+ AD=9.6e-13 AS=5.4e-13 PD=4.96e-06 PS=2.54e-06 NRD=0.24 NRS=0.135
mXI3.XI2.MM14 N_XI3.XI2.NET24_XI3.XI2.MM14_d N_CLK_B_XI3.XI2.MM14_g
+ N_XI3.XI2.NET39_XI3.XI2.MM14_s N_VSS!_XI4.XI5.MM14_b nch L=1.8e-07 W=2e-06
+ AD=5.4e-13 AS=5.4e-13 PD=2.54e-06 PS=2.54e-06 NRD=0.135 NRS=0.135
mXI3.XI2.MM13 N_XI3.XI2.NET24_XI3.XI2.MM13_d N_CNT<5>_XI3.XI2.MM13_g
+ N_VSS!_XI3.XI2.MM13_s N_VSS!_XI4.XI5.MM14_b nch L=1.8e-07 W=2e-06 AD=5.4e-13
+ AS=5.4e-13 PD=2.54e-06 PS=2.54e-06 NRD=0.135 NRS=0.135
mXI3.XI2.MM12 N_CNT<5>_XI3.XI2.MM12_d N_XI3.XI2.NET39_XI3.XI2.MM12_g
+ N_VSS!_XI3.XI2.MM12_s N_VSS!_XI4.XI5.MM14_b nch L=1.8e-07 W=2e-06 AD=9.6e-13
+ AS=5.4e-13 PD=4.96e-06 PS=2.54e-06 NRD=0.24 NRS=0.135
mXI3.XI2.MM2 N_XI3.XI2.NET40_XI3.XI2.MM2_d N_XI3.XI2.NET23_XI3.XI2.MM2_g
+ N_VSS!_XI3.XI2.MM2_s N_VSS!_XI4.XI5.MM14_b nch L=1.8e-07 W=2e-06 AD=9.6e-13
+ AS=5.4e-13 PD=4.96e-06 PS=2.54e-06 NRD=0.24 NRS=0.135
mXI3.XI2.MM6 N_XI3.XI2.NET48_XI3.XI2.MM6_d N_XI3.XI2.NET40_XI3.XI2.MM6_g
+ N_VSS!_XI3.XI2.MM6_s N_VSS!_XI4.XI5.MM14_b nch L=1.8e-07 W=2e-06 AD=9.6e-13
+ AS=5.4e-13 PD=4.96e-06 PS=2.54e-06 NRD=0.24 NRS=0.135
mXI3.XI2.MM1 N_NET6<2>_XI3.XI2.MM1_d N_CLK_B_XI3.XI2.MM1_g
+ N_XI3.XI2.NET23_XI3.XI2.MM1_s N_VSS!_XI4.XI5.MM14_b nch L=1.8e-07 W=2e-06
+ AD=9.6e-13 AS=5.4e-13 PD=4.96e-06 PS=2.54e-06 NRD=0.24 NRS=0.135
mXI3.XI2.MM8 N_XI3.XI2.NET48_XI3.XI2.MM8_d N_CLK_XI3.XI2.MM8_g
+ N_XI3.XI2.NET23_XI3.XI2.MM8_s N_VSS!_XI4.XI5.MM14_b nch L=1.8e-07 W=2e-06
+ AD=9.6e-13 AS=5.4e-13 PD=4.96e-06 PS=2.54e-06 NRD=0.24 NRS=0.135
mXI3.XI3.MM10 N_XI3.XI3.NET40_XI3.XI3.MM10_d N_CLK_XI3.XI3.MM10_g
+ N_XI3.XI3.NET39_XI3.XI3.MM10_s N_VSS!_XI4.XI5.MM14_b nch L=1.8e-07 W=2e-06
+ AD=9.6e-13 AS=5.4e-13 PD=4.96e-06 PS=2.54e-06 NRD=0.24 NRS=0.135
mXI3.XI3.MM14 N_XI3.XI3.NET24_XI3.XI3.MM14_d N_CLK_B_XI3.XI3.MM14_g
+ N_XI3.XI3.NET39_XI3.XI3.MM14_s N_VSS!_XI4.XI5.MM14_b nch L=1.8e-07 W=2e-06
+ AD=5.4e-13 AS=5.4e-13 PD=2.54e-06 PS=2.54e-06 NRD=0.135 NRS=0.135
mXI3.XI3.MM13 N_XI3.XI3.NET24_XI3.XI3.MM13_d N_CNT<4>_XI3.XI3.MM13_g
+ N_VSS!_XI3.XI3.MM13_s N_VSS!_XI4.XI5.MM14_b nch L=1.8e-07 W=2e-06 AD=5.4e-13
+ AS=5.4e-13 PD=2.54e-06 PS=2.54e-06 NRD=0.135 NRS=0.135
mXI3.XI3.MM12 N_CNT<4>_XI3.XI3.MM12_d N_XI3.XI3.NET39_XI3.XI3.MM12_g
+ N_VSS!_XI3.XI3.MM12_s N_VSS!_XI4.XI5.MM14_b nch L=1.8e-07 W=2e-06 AD=9.6e-13
+ AS=5.4e-13 PD=4.96e-06 PS=2.54e-06 NRD=0.24 NRS=0.135
mXI3.XI3.MM2 N_XI3.XI3.NET40_XI3.XI3.MM2_d N_XI3.XI3.NET23_XI3.XI3.MM2_g
+ N_VSS!_XI3.XI3.MM2_s N_VSS!_XI4.XI5.MM14_b nch L=1.8e-07 W=2e-06 AD=9.6e-13
+ AS=5.4e-13 PD=4.96e-06 PS=2.54e-06 NRD=0.24 NRS=0.135
mXI3.XI3.MM6 N_XI3.XI3.NET48_XI3.XI3.MM6_d N_XI3.XI3.NET40_XI3.XI3.MM6_g
+ N_VSS!_XI3.XI3.MM6_s N_VSS!_XI4.XI5.MM14_b nch L=1.8e-07 W=2e-06 AD=9.6e-13
+ AS=5.4e-13 PD=4.96e-06 PS=2.54e-06 NRD=0.24 NRS=0.135
mXI3.XI3.MM1 N_NET6<3>_XI3.XI3.MM1_d N_CLK_B_XI3.XI3.MM1_g
+ N_XI3.XI3.NET23_XI3.XI3.MM1_s N_VSS!_XI4.XI5.MM14_b nch L=1.8e-07 W=2e-06
+ AD=9.6e-13 AS=5.4e-13 PD=4.96e-06 PS=2.54e-06 NRD=0.24 NRS=0.135
mXI3.XI3.MM8 N_XI3.XI3.NET48_XI3.XI3.MM8_d N_CLK_XI3.XI3.MM8_g
+ N_XI3.XI3.NET23_XI3.XI3.MM8_s N_VSS!_XI4.XI5.MM14_b nch L=1.8e-07 W=2e-06
+ AD=9.6e-13 AS=5.4e-13 PD=4.96e-06 PS=2.54e-06 NRD=0.24 NRS=0.135
mXI3.XI4.MM10 N_XI3.XI4.NET40_XI3.XI4.MM10_d N_CLK_XI3.XI4.MM10_g
+ N_XI3.XI4.NET39_XI3.XI4.MM10_s N_VSS!_XI4.XI5.MM14_b nch L=1.8e-07 W=2e-06
+ AD=9.6e-13 AS=5.4e-13 PD=4.96e-06 PS=2.54e-06 NRD=0.24 NRS=0.135
mXI3.XI4.MM14 N_XI3.XI4.NET24_XI3.XI4.MM14_d N_CLK_B_XI3.XI4.MM14_g
+ N_XI3.XI4.NET39_XI3.XI4.MM14_s N_VSS!_XI4.XI5.MM14_b nch L=1.8e-07 W=2e-06
+ AD=5.4e-13 AS=5.4e-13 PD=2.54e-06 PS=2.54e-06 NRD=0.135 NRS=0.135
mXI3.XI4.MM13 N_XI3.XI4.NET24_XI3.XI4.MM13_d N_CNT<3>_XI3.XI4.MM13_g
+ N_VSS!_XI3.XI4.MM13_s N_VSS!_XI4.XI5.MM14_b nch L=1.8e-07 W=2e-06 AD=5.4e-13
+ AS=5.4e-13 PD=2.54e-06 PS=2.54e-06 NRD=0.135 NRS=0.135
mXI3.XI4.MM12 N_CNT<3>_XI3.XI4.MM12_d N_XI3.XI4.NET39_XI3.XI4.MM12_g
+ N_VSS!_XI3.XI4.MM12_s N_VSS!_XI4.XI5.MM14_b nch L=1.8e-07 W=2e-06 AD=9.6e-13
+ AS=5.4e-13 PD=4.96e-06 PS=2.54e-06 NRD=0.24 NRS=0.135
mXI3.XI4.MM2 N_XI3.XI4.NET40_XI3.XI4.MM2_d N_XI3.XI4.NET23_XI3.XI4.MM2_g
+ N_VSS!_XI3.XI4.MM2_s N_VSS!_XI4.XI5.MM14_b nch L=1.8e-07 W=2e-06 AD=9.6e-13
+ AS=5.4e-13 PD=4.96e-06 PS=2.54e-06 NRD=0.24 NRS=0.135
mXI3.XI4.MM6 N_XI3.XI4.NET48_XI3.XI4.MM6_d N_XI3.XI4.NET40_XI3.XI4.MM6_g
+ N_VSS!_XI3.XI4.MM6_s N_VSS!_XI4.XI5.MM14_b nch L=1.8e-07 W=2e-06 AD=9.6e-13
+ AS=5.4e-13 PD=4.96e-06 PS=2.54e-06 NRD=0.24 NRS=0.135
mXI3.XI4.MM1 N_NET6<4>_XI3.XI4.MM1_d N_CLK_B_XI3.XI4.MM1_g
+ N_XI3.XI4.NET23_XI3.XI4.MM1_s N_VSS!_XI4.XI5.MM14_b nch L=1.8e-07 W=2e-06
+ AD=9.6e-13 AS=5.4e-13 PD=4.96e-06 PS=2.54e-06 NRD=0.24 NRS=0.135
mXI3.XI4.MM8 N_XI3.XI4.NET48_XI3.XI4.MM8_d N_CLK_XI3.XI4.MM8_g
+ N_XI3.XI4.NET23_XI3.XI4.MM8_s N_VSS!_XI4.XI5.MM14_b nch L=1.8e-07 W=2e-06
+ AD=9.6e-13 AS=5.4e-13 PD=4.96e-06 PS=2.54e-06 NRD=0.24 NRS=0.135
mXI3.XI5.MM10 N_XI3.XI5.NET40_XI3.XI5.MM10_d N_CLK_XI3.XI5.MM10_g
+ N_XI3.XI5.NET39_XI3.XI5.MM10_s N_VSS!_XI4.XI5.MM14_b nch L=1.8e-07 W=2e-06
+ AD=9.6e-13 AS=5.4e-13 PD=4.96e-06 PS=2.54e-06 NRD=0.24 NRS=0.135
mXI3.XI5.MM14 N_XI3.XI5.NET24_XI3.XI5.MM14_d N_CLK_B_XI3.XI5.MM14_g
+ N_XI3.XI5.NET39_XI3.XI5.MM14_s N_VSS!_XI4.XI5.MM14_b nch L=1.8e-07 W=2e-06
+ AD=5.4e-13 AS=5.4e-13 PD=2.54e-06 PS=2.54e-06 NRD=0.135 NRS=0.135
mXI3.XI5.MM13 N_XI3.XI5.NET24_XI3.XI5.MM13_d N_CNT<2>_XI3.XI5.MM13_g
+ N_VSS!_XI3.XI5.MM13_s N_VSS!_XI4.XI5.MM14_b nch L=1.8e-07 W=2e-06 AD=5.4e-13
+ AS=5.4e-13 PD=2.54e-06 PS=2.54e-06 NRD=0.135 NRS=0.135
mXI3.XI5.MM12 N_CNT<2>_XI3.XI5.MM12_d N_XI3.XI5.NET39_XI3.XI5.MM12_g
+ N_VSS!_XI3.XI5.MM12_s N_VSS!_XI4.XI5.MM14_b nch L=1.8e-07 W=2e-06 AD=9.6e-13
+ AS=5.4e-13 PD=4.96e-06 PS=2.54e-06 NRD=0.24 NRS=0.135
mXI3.XI5.MM2 N_XI3.XI5.NET40_XI3.XI5.MM2_d N_XI3.XI5.NET23_XI3.XI5.MM2_g
+ N_VSS!_XI3.XI5.MM2_s N_VSS!_XI4.XI5.MM14_b nch L=1.8e-07 W=2e-06 AD=9.6e-13
+ AS=5.4e-13 PD=4.96e-06 PS=2.54e-06 NRD=0.24 NRS=0.135
mXI3.XI5.MM6 N_XI3.XI5.NET48_XI3.XI5.MM6_d N_XI3.XI5.NET40_XI3.XI5.MM6_g
+ N_VSS!_XI3.XI5.MM6_s N_VSS!_XI4.XI5.MM14_b nch L=1.8e-07 W=2e-06 AD=9.6e-13
+ AS=5.4e-13 PD=4.96e-06 PS=2.54e-06 NRD=0.24 NRS=0.135
mXI3.XI5.MM1 N_NET6<5>_XI3.XI5.MM1_d N_CLK_B_XI3.XI5.MM1_g
+ N_XI3.XI5.NET23_XI3.XI5.MM1_s N_VSS!_XI4.XI5.MM14_b nch L=1.8e-07 W=2e-06
+ AD=9.6e-13 AS=5.4e-13 PD=4.96e-06 PS=2.54e-06 NRD=0.24 NRS=0.135
mXI3.XI5.MM8 N_XI3.XI5.NET48_XI3.XI5.MM8_d N_CLK_XI3.XI5.MM8_g
+ N_XI3.XI5.NET23_XI3.XI5.MM8_s N_VSS!_XI4.XI5.MM14_b nch L=1.8e-07 W=2e-06
+ AD=9.6e-13 AS=5.4e-13 PD=4.96e-06 PS=2.54e-06 NRD=0.24 NRS=0.135
mXI3.XI6.MM10 N_XI3.XI6.NET40_XI3.XI6.MM10_d N_CLK_XI3.XI6.MM10_g
+ N_XI3.XI6.NET39_XI3.XI6.MM10_s N_VSS!_XI4.XI5.MM14_b nch L=1.8e-07 W=2e-06
+ AD=9.6e-13 AS=5.4e-13 PD=4.96e-06 PS=2.54e-06 NRD=0.24 NRS=0.135
mXI3.XI6.MM14 N_XI3.XI6.NET24_XI3.XI6.MM14_d N_CLK_B_XI3.XI6.MM14_g
+ N_XI3.XI6.NET39_XI3.XI6.MM14_s N_VSS!_XI4.XI5.MM14_b nch L=1.8e-07 W=2e-06
+ AD=5.4e-13 AS=5.4e-13 PD=2.54e-06 PS=2.54e-06 NRD=0.135 NRS=0.135
mXI3.XI6.MM13 N_XI3.XI6.NET24_XI3.XI6.MM13_d N_CNT<1>_XI3.XI6.MM13_g
+ N_VSS!_XI3.XI6.MM13_s N_VSS!_XI4.XI5.MM14_b nch L=1.8e-07 W=2e-06 AD=5.4e-13
+ AS=5.4e-13 PD=2.54e-06 PS=2.54e-06 NRD=0.135 NRS=0.135
mXI3.XI6.MM12 N_CNT<1>_XI3.XI6.MM12_d N_XI3.XI6.NET39_XI3.XI6.MM12_g
+ N_VSS!_XI3.XI6.MM12_s N_VSS!_XI4.XI5.MM14_b nch L=1.8e-07 W=2e-06 AD=9.6e-13
+ AS=5.4e-13 PD=4.96e-06 PS=2.54e-06 NRD=0.24 NRS=0.135
mXI3.XI6.MM2 N_XI3.XI6.NET40_XI3.XI6.MM2_d N_XI3.XI6.NET23_XI3.XI6.MM2_g
+ N_VSS!_XI3.XI6.MM2_s N_VSS!_XI4.XI5.MM14_b nch L=1.8e-07 W=2e-06 AD=9.6e-13
+ AS=5.4e-13 PD=4.96e-06 PS=2.54e-06 NRD=0.24 NRS=0.135
mXI3.XI6.MM6 N_XI3.XI6.NET48_XI3.XI6.MM6_d N_XI3.XI6.NET40_XI3.XI6.MM6_g
+ N_VSS!_XI3.XI6.MM6_s N_VSS!_XI4.XI5.MM14_b nch L=1.8e-07 W=2e-06 AD=9.6e-13
+ AS=5.4e-13 PD=4.96e-06 PS=2.54e-06 NRD=0.24 NRS=0.135
mXI3.XI6.MM1 N_NET6<6>_XI3.XI6.MM1_d N_CLK_B_XI3.XI6.MM1_g
+ N_XI3.XI6.NET23_XI3.XI6.MM1_s N_VSS!_XI4.XI5.MM14_b nch L=1.8e-07 W=2e-06
+ AD=9.6e-13 AS=5.4e-13 PD=4.96e-06 PS=2.54e-06 NRD=0.24 NRS=0.135
mXI3.XI6.MM8 N_XI3.XI6.NET48_XI3.XI6.MM8_d N_CLK_XI3.XI6.MM8_g
+ N_XI3.XI6.NET23_XI3.XI6.MM8_s N_VSS!_XI4.XI5.MM14_b nch L=1.8e-07 W=2e-06
+ AD=9.6e-13 AS=5.4e-13 PD=4.96e-06 PS=2.54e-06 NRD=0.24 NRS=0.135
mXI3.XI7.MM10 N_XI3.XI7.NET40_XI3.XI7.MM10_d N_CLK_XI3.XI7.MM10_g
+ N_XI3.XI7.NET39_XI3.XI7.MM10_s N_VSS!_XI4.XI5.MM14_b nch L=1.8e-07 W=2e-06
+ AD=9.6e-13 AS=5.4e-13 PD=4.96e-06 PS=2.54e-06 NRD=0.24 NRS=0.135
mXI3.XI7.MM14 N_XI3.XI7.NET24_XI3.XI7.MM14_d N_CLK_B_XI3.XI7.MM14_g
+ N_XI3.XI7.NET39_XI3.XI7.MM14_s N_VSS!_XI4.XI5.MM14_b nch L=1.8e-07 W=2e-06
+ AD=5.4e-13 AS=5.4e-13 PD=2.54e-06 PS=2.54e-06 NRD=0.135 NRS=0.135
mXI3.XI7.MM13 N_XI3.XI7.NET24_XI3.XI7.MM13_d N_CNT<0>_XI3.XI7.MM13_g
+ N_VSS!_XI3.XI7.MM13_s N_VSS!_XI4.XI5.MM14_b nch L=1.8e-07 W=2e-06 AD=5.4e-13
+ AS=5.4e-13 PD=2.54e-06 PS=2.54e-06 NRD=0.135 NRS=0.135
mXI3.XI7.MM12 N_CNT<0>_XI3.XI7.MM12_d N_XI3.XI7.NET39_XI3.XI7.MM12_g
+ N_VSS!_XI3.XI7.MM12_s N_VSS!_XI4.XI5.MM14_b nch L=1.8e-07 W=2e-06 AD=9.6e-13
+ AS=5.4e-13 PD=4.96e-06 PS=2.54e-06 NRD=0.24 NRS=0.135
mXI3.XI7.MM2 N_XI3.XI7.NET40_XI3.XI7.MM2_d N_XI3.XI7.NET23_XI3.XI7.MM2_g
+ N_VSS!_XI3.XI7.MM2_s N_VSS!_XI4.XI5.MM14_b nch L=1.8e-07 W=2e-06 AD=9.6e-13
+ AS=5.4e-13 PD=4.96e-06 PS=2.54e-06 NRD=0.24 NRS=0.135
mXI3.XI7.MM6 N_XI3.XI7.NET48_XI3.XI7.MM6_d N_XI3.XI7.NET40_XI3.XI7.MM6_g
+ N_VSS!_XI3.XI7.MM6_s N_VSS!_XI4.XI5.MM14_b nch L=1.8e-07 W=2e-06 AD=9.6e-13
+ AS=5.4e-13 PD=4.96e-06 PS=2.54e-06 NRD=0.24 NRS=0.135
mXI3.XI7.MM1 N_NET6<7>_XI3.XI7.MM1_d N_CLK_B_XI3.XI7.MM1_g
+ N_XI3.XI7.NET23_XI3.XI7.MM1_s N_VSS!_XI4.XI5.MM14_b nch L=1.8e-07 W=2e-06
+ AD=9.6e-13 AS=5.4e-13 PD=4.96e-06 PS=2.54e-06 NRD=0.24 NRS=0.135
mXI3.XI7.MM8 N_XI3.XI7.NET48_XI3.XI7.MM8_d N_CLK_XI3.XI7.MM8_g
+ N_XI3.XI7.NET23_XI3.XI7.MM8_s N_VSS!_XI4.XI5.MM14_b nch L=1.8e-07 W=2e-06
+ AD=9.6e-13 AS=5.4e-13 PD=4.96e-06 PS=2.54e-06 NRD=0.24 NRS=0.135
mXI3.XI0.MM11 N_XI3.XI0.NET40_XI3.XI0.MM11_d N_CLK_B_XI3.XI0.MM11_g
+ N_XI3.XI0.NET39_XI3.XI0.MM11_s N_VDD!_XI4.XI5.MM13_b pch L=1.8e-07 W=4e-06
+ AD=1.92e-12 AS=1.08e-12 PD=8.96e-06 PS=4.54e-06 NRD=0.12 NRS=0.0675
mXI3.XI0.MM17 N_XI3.XI0.NET24_XI3.XI0.MM17_d N_CLK_XI3.XI0.MM17_g
+ N_XI3.XI0.NET39_XI3.XI0.MM17_s N_VDD!_XI4.XI5.MM13_b pch L=1.8e-07 W=4e-06
+ AD=1.08e-12 AS=1.08e-12 PD=4.54e-06 PS=4.54e-06 NRD=0.0675 NRS=0.0675
mXI3.XI0.MM16 N_XI3.XI0.NET24_XI3.XI0.MM16_d N_CNT<7>_XI3.XI0.MM16_g
+ N_VDD!_XI3.XI0.MM16_s N_VDD!_XI4.XI5.MM13_b pch L=1.8e-07 W=4e-06 AD=1.08e-12
+ AS=1.08e-12 PD=4.54e-06 PS=4.54e-06 NRD=0.0675 NRS=0.0675
mXI3.XI0.MM15 N_CNT<7>_XI3.XI0.MM15_d N_XI3.XI0.NET39_XI3.XI0.MM15_g
+ N_VDD!_XI3.XI0.MM15_s N_VDD!_XI4.XI5.MM13_b pch L=1.8e-07 W=4e-06 AD=1.92e-12
+ AS=1.08e-12 PD=8.96e-06 PS=4.54e-06 NRD=0.12 NRS=0.0675
mXI3.XI0.MM3 N_XI3.XI0.NET40_XI3.XI0.MM3_d N_XI3.XI0.NET23_XI3.XI0.MM3_g
+ N_VDD!_XI3.XI0.MM3_s N_VDD!_XI4.XI5.MM13_b pch L=1.8e-07 W=4e-06 AD=1.92e-12
+ AS=1.08e-12 PD=8.96e-06 PS=4.54e-06 NRD=0.12 NRS=0.0675
mXI3.XI0.MM7 N_XI3.XI0.NET48_XI3.XI0.MM7_d N_XI3.XI0.NET40_XI3.XI0.MM7_g
+ N_VDD!_XI3.XI0.MM7_s N_VDD!_XI4.XI5.MM13_b pch L=1.8e-07 W=4e-06 AD=1.92e-12
+ AS=1.08e-12 PD=8.96e-06 PS=4.54e-06 NRD=0.12 NRS=0.0675
mXI3.XI0.MM0 N_NET6<0>_XI3.XI0.MM0_d N_CLK_XI3.XI0.MM0_g
+ N_XI3.XI0.NET23_XI3.XI0.MM0_s N_VDD!_XI4.XI5.MM13_b pch L=1.8e-07 W=4e-06
+ AD=1.92e-12 AS=1.08e-12 PD=8.96e-06 PS=4.54e-06 NRD=0.12 NRS=0.0675
mXI3.XI0.MM9 N_XI3.XI0.NET48_XI3.XI0.MM9_d N_CLK_B_XI3.XI0.MM9_g
+ N_XI3.XI0.NET23_XI3.XI0.MM9_s N_VDD!_XI4.XI5.MM13_b pch L=1.8e-07 W=4e-06
+ AD=1.92e-12 AS=1.08e-12 PD=8.96e-06 PS=4.54e-06 NRD=0.12 NRS=0.0675
mXI3.XI1.MM11 N_XI3.XI1.NET40_XI3.XI1.MM11_d N_CLK_B_XI3.XI1.MM11_g
+ N_XI3.XI1.NET39_XI3.XI1.MM11_s N_VDD!_XI4.XI5.MM13_b pch L=1.8e-07 W=4e-06
+ AD=1.92e-12 AS=1.08e-12 PD=8.96e-06 PS=4.54e-06 NRD=0.12 NRS=0.0675
mXI3.XI1.MM17 N_XI3.XI1.NET24_XI3.XI1.MM17_d N_CLK_XI3.XI1.MM17_g
+ N_XI3.XI1.NET39_XI3.XI1.MM17_s N_VDD!_XI4.XI5.MM13_b pch L=1.8e-07 W=4e-06
+ AD=1.08e-12 AS=1.08e-12 PD=4.54e-06 PS=4.54e-06 NRD=0.0675 NRS=0.0675
mXI3.XI1.MM16 N_XI3.XI1.NET24_XI3.XI1.MM16_d N_CNT<6>_XI3.XI1.MM16_g
+ N_VDD!_XI3.XI1.MM16_s N_VDD!_XI4.XI5.MM13_b pch L=1.8e-07 W=4e-06 AD=1.08e-12
+ AS=1.08e-12 PD=4.54e-06 PS=4.54e-06 NRD=0.0675 NRS=0.0675
mXI3.XI1.MM15 N_CNT<6>_XI3.XI1.MM15_d N_XI3.XI1.NET39_XI3.XI1.MM15_g
+ N_VDD!_XI3.XI1.MM15_s N_VDD!_XI4.XI5.MM13_b pch L=1.8e-07 W=4e-06 AD=1.92e-12
+ AS=1.08e-12 PD=8.96e-06 PS=4.54e-06 NRD=0.12 NRS=0.0675
mXI3.XI1.MM3 N_XI3.XI1.NET40_XI3.XI1.MM3_d N_XI3.XI1.NET23_XI3.XI1.MM3_g
+ N_VDD!_XI3.XI1.MM3_s N_VDD!_XI4.XI5.MM13_b pch L=1.8e-07 W=4e-06 AD=1.92e-12
+ AS=1.08e-12 PD=8.96e-06 PS=4.54e-06 NRD=0.12 NRS=0.0675
mXI3.XI1.MM7 N_XI3.XI1.NET48_XI3.XI1.MM7_d N_XI3.XI1.NET40_XI3.XI1.MM7_g
+ N_VDD!_XI3.XI1.MM7_s N_VDD!_XI4.XI5.MM13_b pch L=1.8e-07 W=4e-06 AD=1.92e-12
+ AS=1.08e-12 PD=8.96e-06 PS=4.54e-06 NRD=0.12 NRS=0.0675
mXI3.XI1.MM0 N_NET6<1>_XI3.XI1.MM0_d N_CLK_XI3.XI1.MM0_g
+ N_XI3.XI1.NET23_XI3.XI1.MM0_s N_VDD!_XI4.XI5.MM13_b pch L=1.8e-07 W=4e-06
+ AD=1.92e-12 AS=1.08e-12 PD=8.96e-06 PS=4.54e-06 NRD=0.12 NRS=0.0675
mXI3.XI1.MM9 N_XI3.XI1.NET48_XI3.XI1.MM9_d N_CLK_B_XI3.XI1.MM9_g
+ N_XI3.XI1.NET23_XI3.XI1.MM9_s N_VDD!_XI4.XI5.MM13_b pch L=1.8e-07 W=4e-06
+ AD=1.92e-12 AS=1.08e-12 PD=8.96e-06 PS=4.54e-06 NRD=0.12 NRS=0.0675
mXI3.XI2.MM11 N_XI3.XI2.NET40_XI3.XI2.MM11_d N_CLK_B_XI3.XI2.MM11_g
+ N_XI3.XI2.NET39_XI3.XI2.MM11_s N_VDD!_XI4.XI5.MM13_b pch L=1.8e-07 W=4e-06
+ AD=1.92e-12 AS=1.08e-12 PD=8.96e-06 PS=4.54e-06 NRD=0.12 NRS=0.0675
mXI3.XI2.MM17 N_XI3.XI2.NET24_XI3.XI2.MM17_d N_CLK_XI3.XI2.MM17_g
+ N_XI3.XI2.NET39_XI3.XI2.MM17_s N_VDD!_XI4.XI5.MM13_b pch L=1.8e-07 W=4e-06
+ AD=1.08e-12 AS=1.08e-12 PD=4.54e-06 PS=4.54e-06 NRD=0.0675 NRS=0.0675
mXI3.XI2.MM16 N_XI3.XI2.NET24_XI3.XI2.MM16_d N_CNT<5>_XI3.XI2.MM16_g
+ N_VDD!_XI3.XI2.MM16_s N_VDD!_XI4.XI5.MM13_b pch L=1.8e-07 W=4e-06 AD=1.08e-12
+ AS=1.08e-12 PD=4.54e-06 PS=4.54e-06 NRD=0.0675 NRS=0.0675
mXI3.XI2.MM15 N_CNT<5>_XI3.XI2.MM15_d N_XI3.XI2.NET39_XI3.XI2.MM15_g
+ N_VDD!_XI3.XI2.MM15_s N_VDD!_XI4.XI5.MM13_b pch L=1.8e-07 W=4e-06 AD=1.92e-12
+ AS=1.08e-12 PD=8.96e-06 PS=4.54e-06 NRD=0.12 NRS=0.0675
mXI3.XI2.MM3 N_XI3.XI2.NET40_XI3.XI2.MM3_d N_XI3.XI2.NET23_XI3.XI2.MM3_g
+ N_VDD!_XI3.XI2.MM3_s N_VDD!_XI4.XI5.MM13_b pch L=1.8e-07 W=4e-06 AD=1.92e-12
+ AS=1.08e-12 PD=8.96e-06 PS=4.54e-06 NRD=0.12 NRS=0.0675
mXI3.XI2.MM7 N_XI3.XI2.NET48_XI3.XI2.MM7_d N_XI3.XI2.NET40_XI3.XI2.MM7_g
+ N_VDD!_XI3.XI2.MM7_s N_VDD!_XI4.XI5.MM13_b pch L=1.8e-07 W=4e-06 AD=1.92e-12
+ AS=1.08e-12 PD=8.96e-06 PS=4.54e-06 NRD=0.12 NRS=0.0675
mXI3.XI2.MM0 N_NET6<2>_XI3.XI2.MM0_d N_CLK_XI3.XI2.MM0_g
+ N_XI3.XI2.NET23_XI3.XI2.MM0_s N_VDD!_XI4.XI5.MM13_b pch L=1.8e-07 W=4e-06
+ AD=1.92e-12 AS=1.08e-12 PD=8.96e-06 PS=4.54e-06 NRD=0.12 NRS=0.0675
mXI3.XI2.MM9 N_XI3.XI2.NET48_XI3.XI2.MM9_d N_CLK_B_XI3.XI2.MM9_g
+ N_XI3.XI2.NET23_XI3.XI2.MM9_s N_VDD!_XI4.XI5.MM13_b pch L=1.8e-07 W=4e-06
+ AD=1.92e-12 AS=1.08e-12 PD=8.96e-06 PS=4.54e-06 NRD=0.12 NRS=0.0675
mXI3.XI3.MM11 N_XI3.XI3.NET40_XI3.XI3.MM11_d N_CLK_B_XI3.XI3.MM11_g
+ N_XI3.XI3.NET39_XI3.XI3.MM11_s N_VDD!_XI4.XI5.MM13_b pch L=1.8e-07 W=4e-06
+ AD=1.92e-12 AS=1.08e-12 PD=8.96e-06 PS=4.54e-06 NRD=0.12 NRS=0.0675
mXI3.XI3.MM17 N_XI3.XI3.NET24_XI3.XI3.MM17_d N_CLK_XI3.XI3.MM17_g
+ N_XI3.XI3.NET39_XI3.XI3.MM17_s N_VDD!_XI4.XI5.MM13_b pch L=1.8e-07 W=4e-06
+ AD=1.08e-12 AS=1.08e-12 PD=4.54e-06 PS=4.54e-06 NRD=0.0675 NRS=0.0675
mXI3.XI3.MM16 N_XI3.XI3.NET24_XI3.XI3.MM16_d N_CNT<4>_XI3.XI3.MM16_g
+ N_VDD!_XI3.XI3.MM16_s N_VDD!_XI4.XI5.MM13_b pch L=1.8e-07 W=4e-06 AD=1.08e-12
+ AS=1.08e-12 PD=4.54e-06 PS=4.54e-06 NRD=0.0675 NRS=0.0675
mXI3.XI3.MM15 N_CNT<4>_XI3.XI3.MM15_d N_XI3.XI3.NET39_XI3.XI3.MM15_g
+ N_VDD!_XI3.XI3.MM15_s N_VDD!_XI4.XI5.MM13_b pch L=1.8e-07 W=4e-06 AD=1.92e-12
+ AS=1.08e-12 PD=8.96e-06 PS=4.54e-06 NRD=0.12 NRS=0.0675
mXI3.XI3.MM3 N_XI3.XI3.NET40_XI3.XI3.MM3_d N_XI3.XI3.NET23_XI3.XI3.MM3_g
+ N_VDD!_XI3.XI3.MM3_s N_VDD!_XI4.XI5.MM13_b pch L=1.8e-07 W=4e-06 AD=1.92e-12
+ AS=1.08e-12 PD=8.96e-06 PS=4.54e-06 NRD=0.12 NRS=0.0675
mXI3.XI3.MM7 N_XI3.XI3.NET48_XI3.XI3.MM7_d N_XI3.XI3.NET40_XI3.XI3.MM7_g
+ N_VDD!_XI3.XI3.MM7_s N_VDD!_XI4.XI5.MM13_b pch L=1.8e-07 W=4e-06 AD=1.92e-12
+ AS=1.08e-12 PD=8.96e-06 PS=4.54e-06 NRD=0.12 NRS=0.0675
mXI3.XI3.MM0 N_NET6<3>_XI3.XI3.MM0_d N_CLK_XI3.XI3.MM0_g
+ N_XI3.XI3.NET23_XI3.XI3.MM0_s N_VDD!_XI4.XI5.MM13_b pch L=1.8e-07 W=4e-06
+ AD=1.92e-12 AS=1.08e-12 PD=8.96e-06 PS=4.54e-06 NRD=0.12 NRS=0.0675
mXI3.XI3.MM9 N_XI3.XI3.NET48_XI3.XI3.MM9_d N_CLK_B_XI3.XI3.MM9_g
+ N_XI3.XI3.NET23_XI3.XI3.MM9_s N_VDD!_XI4.XI5.MM13_b pch L=1.8e-07 W=4e-06
+ AD=1.92e-12 AS=1.08e-12 PD=8.96e-06 PS=4.54e-06 NRD=0.12 NRS=0.0675
mXI3.XI4.MM11 N_XI3.XI4.NET40_XI3.XI4.MM11_d N_CLK_B_XI3.XI4.MM11_g
+ N_XI3.XI4.NET39_XI3.XI4.MM11_s N_VDD!_XI4.XI5.MM13_b pch L=1.8e-07 W=4e-06
+ AD=1.92e-12 AS=1.08e-12 PD=8.96e-06 PS=4.54e-06 NRD=0.12 NRS=0.0675
mXI3.XI4.MM17 N_XI3.XI4.NET24_XI3.XI4.MM17_d N_CLK_XI3.XI4.MM17_g
+ N_XI3.XI4.NET39_XI3.XI4.MM17_s N_VDD!_XI4.XI5.MM13_b pch L=1.8e-07 W=4e-06
+ AD=1.08e-12 AS=1.08e-12 PD=4.54e-06 PS=4.54e-06 NRD=0.0675 NRS=0.0675
mXI3.XI4.MM16 N_XI3.XI4.NET24_XI3.XI4.MM16_d N_CNT<3>_XI3.XI4.MM16_g
+ N_VDD!_XI3.XI4.MM16_s N_VDD!_XI4.XI5.MM13_b pch L=1.8e-07 W=4e-06 AD=1.08e-12
+ AS=1.08e-12 PD=4.54e-06 PS=4.54e-06 NRD=0.0675 NRS=0.0675
mXI3.XI4.MM15 N_CNT<3>_XI3.XI4.MM15_d N_XI3.XI4.NET39_XI3.XI4.MM15_g
+ N_VDD!_XI3.XI4.MM15_s N_VDD!_XI4.XI5.MM13_b pch L=1.8e-07 W=4e-06 AD=1.92e-12
+ AS=1.08e-12 PD=8.96e-06 PS=4.54e-06 NRD=0.12 NRS=0.0675
mXI3.XI4.MM3 N_XI3.XI4.NET40_XI3.XI4.MM3_d N_XI3.XI4.NET23_XI3.XI4.MM3_g
+ N_VDD!_XI3.XI4.MM3_s N_VDD!_XI4.XI5.MM13_b pch L=1.8e-07 W=4e-06 AD=1.92e-12
+ AS=1.08e-12 PD=8.96e-06 PS=4.54e-06 NRD=0.12 NRS=0.0675
mXI3.XI4.MM7 N_XI3.XI4.NET48_XI3.XI4.MM7_d N_XI3.XI4.NET40_XI3.XI4.MM7_g
+ N_VDD!_XI3.XI4.MM7_s N_VDD!_XI4.XI5.MM13_b pch L=1.8e-07 W=4e-06 AD=1.92e-12
+ AS=1.08e-12 PD=8.96e-06 PS=4.54e-06 NRD=0.12 NRS=0.0675
mXI3.XI4.MM0 N_NET6<4>_XI3.XI4.MM0_d N_CLK_XI3.XI4.MM0_g
+ N_XI3.XI4.NET23_XI3.XI4.MM0_s N_VDD!_XI4.XI5.MM13_b pch L=1.8e-07 W=4e-06
+ AD=1.92e-12 AS=1.08e-12 PD=8.96e-06 PS=4.54e-06 NRD=0.12 NRS=0.0675
mXI3.XI4.MM9 N_XI3.XI4.NET48_XI3.XI4.MM9_d N_CLK_B_XI3.XI4.MM9_g
+ N_XI3.XI4.NET23_XI3.XI4.MM9_s N_VDD!_XI4.XI5.MM13_b pch L=1.8e-07 W=4e-06
+ AD=1.92e-12 AS=1.08e-12 PD=8.96e-06 PS=4.54e-06 NRD=0.12 NRS=0.0675
mXI3.XI5.MM11 N_XI3.XI5.NET40_XI3.XI5.MM11_d N_CLK_B_XI3.XI5.MM11_g
+ N_XI3.XI5.NET39_XI3.XI5.MM11_s N_VDD!_XI4.XI5.MM13_b pch L=1.8e-07 W=4e-06
+ AD=1.92e-12 AS=1.08e-12 PD=8.96e-06 PS=4.54e-06 NRD=0.12 NRS=0.0675
mXI3.XI5.MM17 N_XI3.XI5.NET24_XI3.XI5.MM17_d N_CLK_XI3.XI5.MM17_g
+ N_XI3.XI5.NET39_XI3.XI5.MM17_s N_VDD!_XI4.XI5.MM13_b pch L=1.8e-07 W=4e-06
+ AD=1.08e-12 AS=1.08e-12 PD=4.54e-06 PS=4.54e-06 NRD=0.0675 NRS=0.0675
mXI3.XI5.MM16 N_XI3.XI5.NET24_XI3.XI5.MM16_d N_CNT<2>_XI3.XI5.MM16_g
+ N_VDD!_XI3.XI5.MM16_s N_VDD!_XI4.XI5.MM13_b pch L=1.8e-07 W=4e-06 AD=1.08e-12
+ AS=1.08e-12 PD=4.54e-06 PS=4.54e-06 NRD=0.0675 NRS=0.0675
mXI3.XI5.MM15 N_CNT<2>_XI3.XI5.MM15_d N_XI3.XI5.NET39_XI3.XI5.MM15_g
+ N_VDD!_XI3.XI5.MM15_s N_VDD!_XI4.XI5.MM13_b pch L=1.8e-07 W=4e-06 AD=1.92e-12
+ AS=1.08e-12 PD=8.96e-06 PS=4.54e-06 NRD=0.12 NRS=0.0675
mXI3.XI5.MM3 N_XI3.XI5.NET40_XI3.XI5.MM3_d N_XI3.XI5.NET23_XI3.XI5.MM3_g
+ N_VDD!_XI3.XI5.MM3_s N_VDD!_XI4.XI5.MM13_b pch L=1.8e-07 W=4e-06 AD=1.92e-12
+ AS=1.08e-12 PD=8.96e-06 PS=4.54e-06 NRD=0.12 NRS=0.0675
mXI3.XI5.MM7 N_XI3.XI5.NET48_XI3.XI5.MM7_d N_XI3.XI5.NET40_XI3.XI5.MM7_g
+ N_VDD!_XI3.XI5.MM7_s N_VDD!_XI4.XI5.MM13_b pch L=1.8e-07 W=4e-06 AD=1.92e-12
+ AS=1.08e-12 PD=8.96e-06 PS=4.54e-06 NRD=0.12 NRS=0.0675
mXI3.XI5.MM0 N_NET6<5>_XI3.XI5.MM0_d N_CLK_XI3.XI5.MM0_g
+ N_XI3.XI5.NET23_XI3.XI5.MM0_s N_VDD!_XI4.XI5.MM13_b pch L=1.8e-07 W=4e-06
+ AD=1.92e-12 AS=1.08e-12 PD=8.96e-06 PS=4.54e-06 NRD=0.12 NRS=0.0675
mXI3.XI5.MM9 N_XI3.XI5.NET48_XI3.XI5.MM9_d N_CLK_B_XI3.XI5.MM9_g
+ N_XI3.XI5.NET23_XI3.XI5.MM9_s N_VDD!_XI4.XI5.MM13_b pch L=1.8e-07 W=4e-06
+ AD=1.92e-12 AS=1.08e-12 PD=8.96e-06 PS=4.54e-06 NRD=0.12 NRS=0.0675
mXI3.XI6.MM11 N_XI3.XI6.NET40_XI3.XI6.MM11_d N_CLK_B_XI3.XI6.MM11_g
+ N_XI3.XI6.NET39_XI3.XI6.MM11_s N_VDD!_XI4.XI5.MM13_b pch L=1.8e-07 W=4e-06
+ AD=1.92e-12 AS=1.08e-12 PD=8.96e-06 PS=4.54e-06 NRD=0.12 NRS=0.0675
mXI3.XI6.MM17 N_XI3.XI6.NET24_XI3.XI6.MM17_d N_CLK_XI3.XI6.MM17_g
+ N_XI3.XI6.NET39_XI3.XI6.MM17_s N_VDD!_XI4.XI5.MM13_b pch L=1.8e-07 W=4e-06
+ AD=1.08e-12 AS=1.08e-12 PD=4.54e-06 PS=4.54e-06 NRD=0.0675 NRS=0.0675
mXI3.XI6.MM16 N_XI3.XI6.NET24_XI3.XI6.MM16_d N_CNT<1>_XI3.XI6.MM16_g
+ N_VDD!_XI3.XI6.MM16_s N_VDD!_XI4.XI5.MM13_b pch L=1.8e-07 W=4e-06 AD=1.08e-12
+ AS=1.08e-12 PD=4.54e-06 PS=4.54e-06 NRD=0.0675 NRS=0.0675
mXI3.XI6.MM15 N_CNT<1>_XI3.XI6.MM15_d N_XI3.XI6.NET39_XI3.XI6.MM15_g
+ N_VDD!_XI3.XI6.MM15_s N_VDD!_XI4.XI5.MM13_b pch L=1.8e-07 W=4e-06 AD=1.92e-12
+ AS=1.08e-12 PD=8.96e-06 PS=4.54e-06 NRD=0.12 NRS=0.0675
mXI3.XI6.MM3 N_XI3.XI6.NET40_XI3.XI6.MM3_d N_XI3.XI6.NET23_XI3.XI6.MM3_g
+ N_VDD!_XI3.XI6.MM3_s N_VDD!_XI4.XI5.MM13_b pch L=1.8e-07 W=4e-06 AD=1.92e-12
+ AS=1.08e-12 PD=8.96e-06 PS=4.54e-06 NRD=0.12 NRS=0.0675
mXI3.XI6.MM7 N_XI3.XI6.NET48_XI3.XI6.MM7_d N_XI3.XI6.NET40_XI3.XI6.MM7_g
+ N_VDD!_XI3.XI6.MM7_s N_VDD!_XI4.XI5.MM13_b pch L=1.8e-07 W=4e-06 AD=1.92e-12
+ AS=1.08e-12 PD=8.96e-06 PS=4.54e-06 NRD=0.12 NRS=0.0675
mXI3.XI6.MM0 N_NET6<6>_XI3.XI6.MM0_d N_CLK_XI3.XI6.MM0_g
+ N_XI3.XI6.NET23_XI3.XI6.MM0_s N_VDD!_XI4.XI5.MM13_b pch L=1.8e-07 W=4e-06
+ AD=1.92e-12 AS=1.08e-12 PD=8.96e-06 PS=4.54e-06 NRD=0.12 NRS=0.0675
mXI3.XI6.MM9 N_XI3.XI6.NET48_XI3.XI6.MM9_d N_CLK_B_XI3.XI6.MM9_g
+ N_XI3.XI6.NET23_XI3.XI6.MM9_s N_VDD!_XI4.XI5.MM13_b pch L=1.8e-07 W=4e-06
+ AD=1.92e-12 AS=1.08e-12 PD=8.96e-06 PS=4.54e-06 NRD=0.12 NRS=0.0675
mXI3.XI7.MM11 N_XI3.XI7.NET40_XI3.XI7.MM11_d N_CLK_B_XI3.XI7.MM11_g
+ N_XI3.XI7.NET39_XI3.XI7.MM11_s N_VDD!_XI4.XI5.MM13_b pch L=1.8e-07 W=4e-06
+ AD=1.92e-12 AS=1.08e-12 PD=8.96e-06 PS=4.54e-06 NRD=0.12 NRS=0.0675
mXI3.XI7.MM17 N_XI3.XI7.NET24_XI3.XI7.MM17_d N_CLK_XI3.XI7.MM17_g
+ N_XI3.XI7.NET39_XI3.XI7.MM17_s N_VDD!_XI4.XI5.MM13_b pch L=1.8e-07 W=4e-06
+ AD=1.08e-12 AS=1.08e-12 PD=4.54e-06 PS=4.54e-06 NRD=0.0675 NRS=0.0675
mXI3.XI7.MM16 N_XI3.XI7.NET24_XI3.XI7.MM16_d N_CNT<0>_XI3.XI7.MM16_g
+ N_VDD!_XI3.XI7.MM16_s N_VDD!_XI4.XI5.MM13_b pch L=1.8e-07 W=4e-06 AD=1.08e-12
+ AS=1.08e-12 PD=4.54e-06 PS=4.54e-06 NRD=0.0675 NRS=0.0675
mXI3.XI7.MM15 N_CNT<0>_XI3.XI7.MM15_d N_XI3.XI7.NET39_XI3.XI7.MM15_g
+ N_VDD!_XI3.XI7.MM15_s N_VDD!_XI4.XI5.MM13_b pch L=1.8e-07 W=4e-06 AD=1.92e-12
+ AS=1.08e-12 PD=8.96e-06 PS=4.54e-06 NRD=0.12 NRS=0.0675
mXI3.XI7.MM3 N_XI3.XI7.NET40_XI3.XI7.MM3_d N_XI3.XI7.NET23_XI3.XI7.MM3_g
+ N_VDD!_XI3.XI7.MM3_s N_VDD!_XI4.XI5.MM13_b pch L=1.8e-07 W=4e-06 AD=1.92e-12
+ AS=1.08e-12 PD=8.96e-06 PS=4.54e-06 NRD=0.12 NRS=0.0675
mXI3.XI7.MM7 N_XI3.XI7.NET48_XI3.XI7.MM7_d N_XI3.XI7.NET40_XI3.XI7.MM7_g
+ N_VDD!_XI3.XI7.MM7_s N_VDD!_XI4.XI5.MM13_b pch L=1.8e-07 W=4e-06 AD=1.92e-12
+ AS=1.08e-12 PD=8.96e-06 PS=4.54e-06 NRD=0.12 NRS=0.0675
mXI3.XI7.MM0 N_NET6<7>_XI3.XI7.MM0_d N_CLK_XI3.XI7.MM0_g
+ N_XI3.XI7.NET23_XI3.XI7.MM0_s N_VDD!_XI4.XI5.MM13_b pch L=1.8e-07 W=4e-06
+ AD=1.92e-12 AS=1.08e-12 PD=8.96e-06 PS=4.54e-06 NRD=0.12 NRS=0.0675
mXI3.XI7.MM9 N_XI3.XI7.NET48_XI3.XI7.MM9_d N_CLK_B_XI3.XI7.MM9_g
+ N_XI3.XI7.NET23_XI3.XI7.MM9_s N_VDD!_XI4.XI5.MM13_b pch L=1.8e-07 W=4e-06
+ AD=1.92e-12 AS=1.08e-12 PD=8.96e-06 PS=4.54e-06 NRD=0.12 NRS=0.0675
*
.include "counter_8bit.pex.sp.counter_8bit.pxi"
*
.ends
*
*
*********add the following lines **********
.lib "PTM180.l" cmos
.MALIAS nmos=nch
.MALIAS pmos=pch

xcounter_8bit  CLK CNT<7> CNT<6> CNT<5> CNT<4> CNT<3> CNT<2> CNT<1> CNT<0> VDD! VSS! counter_8bit

vdd vdd! 0 1.8
vss vss! 0 0

VCLK   CLK    0  PULSE(0   1.8  2n  0.1n  0.1n  0.8n  2n)

*.ic V(cnt<0>)=1.8 V(CNT<1>)=1.8 V(CNT<2>)=1.8 V(CNT<3>)=1.8 V(CNT<4>)=1.8 V(CNT<5>)=1.8 V(CNT<6>)=1.8 V(CNT<7>)=1.8
.ic V(cnt<0>)=0 V(CNT<1>)=0 V(CNT<2>)=0 V(CNT<3>)=0 V(CNT<4>)=0 V(CNT<5>)=0 V(CNT<6>)=0 V(CNT<7>)=0

.trans 1ps 512ns

.option post=2
.end
